* Extracted by KLayout with GF180MCU LVS runset on : 24/04/2026 02:18

.SUBCKT ROW MODE SW_REC SW_RECb E REC GND RSTn Q Qb SW_IPG SW_IPGb IPG VDD CLK
+ D MODEb
M$1 \$2 MODE VDD VDD pfet_03v3 L=0.28U W=1U AS=0.65P AD=0.42P PS=3.3U PD=1.84U
M$2 VDD \$3 \$2 VDD pfet_03v3 L=0.28U W=1U AS=0.42P AD=0.735P PS=1.84U PD=2.47U
M$3 SW_REC \$2 VDD VDD pfet_03v3 L=0.28U W=1U AS=0.735P AD=0.64P PS=2.47U
+ PD=3.28U
M$4 SW_RECb SW_REC VDD VDD pfet_03v3 L=0.28U W=1U AS=0.55P AD=0.65P PS=3.1U
+ PD=3.3U
M$5 REC SW_RECb E VDD pfet_03v3 L=0.28U W=1U AS=0.65P AD=0.65P PS=3.3U PD=3.3U
M$6 \$21 CLK VDD VDD pfet_03v3 L=0.28U W=1U AS=0.65P AD=0.65P PS=3.3U PD=3.3U
M$7 \$22 \$21 VDD VDD pfet_03v3 L=0.28U W=1U AS=0.64P AD=0.63P PS=3.28U PD=3.26U
M$8 \$64 \$22 VDD VDD pfet_03v3 L=0.28U W=1U AS=0.54P AD=0.63P PS=3.08U PD=3.26U
M$9 \$24 D \$64 VDD pfet_03v3 L=0.28U W=1U AS=0.605P AD=0.63P PS=3.21U PD=3.26U
M$10 \$30 \$28 VDD VDD pfet_03v3 L=0.28U W=1U AS=0.65P AD=0.65P PS=3.3U PD=3.3U
M$11 \$65 \$30 \$28 VDD pfet_03v3 L=0.28U W=1U AS=0.65P AD=0.65P PS=3.3U PD=3.3U
M$12 VDD \$22 \$65 VDD pfet_03v3 L=0.28U W=1U AS=0.65P AD=0.65P PS=3.3U PD=3.3U
M$13 \$3 \$30 VDD VDD pfet_03v3 L=0.28U W=1U AS=0.65P AD=0.65P PS=3.3U PD=3.3U
M$14 Q \$30 VDD VDD pfet_03v3 L=0.28U W=1U AS=0.65P AD=0.65P PS=3.3U PD=3.3U
M$15 Qb Q VDD VDD pfet_03v3 L=0.28U W=1U AS=0.65P AD=0.65P PS=3.3U PD=3.3U
M$16 \$34 MODEb VDD VDD pfet_03v3 L=0.28U W=1U AS=0.65P AD=0.42P PS=3.3U
+ PD=1.84U
M$17 VDD \$3 \$34 VDD pfet_03v3 L=0.28U W=1U AS=0.42P AD=0.735P PS=1.84U
+ PD=2.47U
M$18 SW_IPG \$34 VDD VDD pfet_03v3 L=0.28U W=1U AS=0.735P AD=0.63P PS=2.47U
+ PD=3.26U
M$19 SW_IPGb SW_IPG VDD VDD pfet_03v3 L=0.28U W=1U AS=0.56P AD=0.65P PS=3.12U
+ PD=3.3U
M$20 IPG SW_IPGb E VDD pfet_03v3 L=0.28U W=1U AS=0.65P AD=0.65P PS=3.3U PD=3.3U
M$21 \$25 \$21 \$24 VDD pfet_03v3 L=0.28U W=1U AS=0.59P AD=0.65P PS=3.18U
+ PD=3.3U
M$22 VDD RSTn \$25 VDD pfet_03v3 L=0.28U W=1U AS=0.65P AD=0.65P PS=3.3U PD=3.3U
M$23 \$25 \$27 VDD VDD pfet_03v3 L=0.28U W=1U AS=0.65P AD=0.65P PS=3.3U PD=3.3U
M$24 VDD \$24 \$27 VDD pfet_03v3 L=0.28U W=1U AS=0.65P AD=0.65P PS=3.3U PD=3.3U
M$25 \$28 \$21 \$27 VDD pfet_03v3 L=0.28U W=1U AS=0.65P AD=0.65P PS=3.3U PD=3.3U
M$26 \$30 RSTn VDD VDD pfet_03v3 L=0.28U W=1U AS=0.65P AD=0.65P PS=3.3U PD=3.3U
M$27 SW_REC \$2 GND GND nfet_03v3 L=0.28U W=0.5U AS=0.2425P AD=0.3125P PS=1.97U
+ PD=2.25U
M$28 SW_RECb SW_REC GND GND nfet_03v3 L=0.28U W=0.5U AS=0.2825P AD=0.315P
+ PS=2.13U PD=2.26U
M$29 \$19 MODE GND GND nfet_03v3 L=0.28U W=1U AS=0.63P AD=0.42P PS=3.26U
+ PD=1.84U
M$30 \$2 \$3 \$19 GND nfet_03v3 L=0.28U W=1U AS=0.42P AD=0.65P PS=1.84U PD=3.3U
M$31 REC SW_REC E GND nfet_03v3 L=0.28U W=1U AS=0.63P AD=0.63P PS=3.26U PD=3.26U
M$32 \$21 CLK GND GND nfet_03v3 L=0.28U W=1U AS=0.61P AD=0.63P PS=3.22U PD=3.26U
M$33 \$22 \$21 GND GND nfet_03v3 L=0.28U W=1U AS=0.61P AD=0.61P PS=3.22U
+ PD=3.22U
M$34 \$23 \$21 GND GND nfet_03v3 L=0.28U W=1U AS=0.575P AD=0.61P PS=3.15U
+ PD=3.22U
M$35 \$24 D \$23 GND nfet_03v3 L=0.28U W=1U AS=0.61P AD=0.61P PS=3.22U PD=3.22U
M$36 \$25 \$22 \$24 GND nfet_03v3 L=0.28U W=1U AS=0.61P AD=0.61P PS=3.22U
+ PD=3.22U
M$37 \$26 RSTn \$25 GND nfet_03v3 L=0.28U W=1U AS=0.61P AD=0.61P PS=3.22U
+ PD=3.22U
M$38 GND \$27 \$26 GND nfet_03v3 L=0.28U W=1U AS=0.61P AD=0.61P PS=3.22U
+ PD=3.22U
M$39 GND \$24 \$27 GND nfet_03v3 L=0.28U W=1U AS=0.61P AD=0.61P PS=3.22U
+ PD=3.22U
M$40 \$28 \$22 \$27 GND nfet_03v3 L=0.28U W=1U AS=0.61P AD=0.61P PS=3.22U
+ PD=3.22U
M$41 \$29 RSTn GND GND nfet_03v3 L=0.28U W=1U AS=0.61P AD=0.61P PS=3.22U
+ PD=3.22U
M$42 \$30 \$28 \$29 GND nfet_03v3 L=0.28U W=1U AS=0.61P AD=0.61P PS=3.22U
+ PD=3.22U
M$43 \$31 \$30 \$28 GND nfet_03v3 L=0.28U W=1U AS=0.61P AD=0.61P PS=3.22U
+ PD=3.22U
M$44 GND \$21 \$31 GND nfet_03v3 L=0.28U W=1U AS=0.61P AD=0.61P PS=3.22U
+ PD=3.22U
M$45 \$3 \$30 GND GND nfet_03v3 L=0.28U W=1U AS=0.61P AD=0.61P PS=3.22U PD=3.22U
M$46 Q \$30 GND GND nfet_03v3 L=0.28U W=1U AS=0.61P AD=0.61P PS=3.22U PD=3.22U
M$47 Qb Q GND GND nfet_03v3 L=0.28U W=1U AS=0.61P AD=0.61P PS=3.22U PD=3.22U
M$48 \$56 MODEb GND GND nfet_03v3 L=0.28U W=1U AS=0.63P AD=0.42P PS=3.26U
+ PD=1.84U
M$49 \$34 \$3 \$56 GND nfet_03v3 L=0.28U W=1U AS=0.42P AD=0.65P PS=1.84U PD=3.3U
M$50 SW_IPG \$34 GND GND nfet_03v3 L=0.28U W=0.5U AS=0.2425P AD=0.31P PS=1.97U
+ PD=2.24U
M$51 SW_IPGb SW_IPG GND GND nfet_03v3 L=0.28U W=0.5U AS=0.285P AD=0.315P
+ PS=2.14U PD=2.26U
M$52 IPG SW_IPG E GND nfet_03v3 L=0.28U W=1U AS=0.63P AD=0.63P PS=3.26U PD=3.26U
.ENDS ROW
