** sch_path: /foss/designs/ENGN1600-Project/full.sch
.subckt full IPG0 EN0 MODE clk E0 REC0 RSTn IPG1 EN1 E1 REC1 IPG2 EN2 E2 REC2 IPG3 EN3 E3 REC3 IPG4 EN4 E4 REC4 IPG5 EN5 E5 REC5
+ IPG6 EN6 E6 REC6 IPG7 EN7 E7 REC7 IPG8 EN8 E8 REC8 IPG9 EN9 E9 REC9 IPG10 EN10 E10 REC10 IPG11 EN11 E11 REC11 IPG12 EN12 E12 REC12
+ IPG13 EN13 E13 REC13 IPG14 EN14 E14 REC14 IPG15 EN15 E15 REC15
*.PININFO RSTn:I MODE:I clk:I EN0:I E0:I IPG0:O REC0:O EN1:I E1:I IPG1:O REC1:O EN2:I E2:I IPG2:O REC2:O EN3:I E3:I IPG3:O REC3:O
*+ EN4:I E4:I IPG4:O REC4:O EN5:I E5:I IPG5:O REC5:O EN6:I E6:I IPG6:O REC6:O EN7:I E7:I IPG7:O REC7:O EN8:I E8:I IPG8:O REC8:O EN9:I E9:I
*+ IPG9:O REC9:O EN10:I E10:I IPG10:O REC10:O EN11:I E11:I IPG11:O REC11:O EN12:I E12:I IPG12:O REC12:O EN13:I E13:I IPG13:O REC13:O EN14:I
*+ E14:I IPG14:O REC14:O EN15:I E15:I IPG15:O REC15:O
x2 vdd RSTn MODE MODE_cfg MODE_cfgb clk GND DFF
x18 IPG0 MODE_cfgb EN0 net1 clk E0 MODE_cfg RSTn REC0 row_fixed
x1 IPG1 MODE_cfgb EN1 net2 clk E1 MODE_cfg RSTn REC1 row_fixed
x3 IPG2 MODE_cfgb EN2 net3 clk E2 MODE_cfg RSTn REC2 row_fixed
x4 IPG3 MODE_cfgb EN3 net4 clk E3 MODE_cfg RSTn REC3 row_fixed
x5 IPG4 MODE_cfgb EN4 net5 clk E4 MODE_cfg RSTn REC4 row_fixed
x6 IPG5 MODE_cfgb EN5 net6 clk E5 MODE_cfg RSTn REC5 row_fixed
x7 IPG6 MODE_cfgb EN6 net7 clk E6 MODE_cfg RSTn REC6 row_fixed
x8 IPG7 MODE_cfgb EN7 net8 clk E7 MODE_cfg RSTn REC7 row_fixed
x9 IPG8 MODE_cfgb EN8 net9 clk E8 MODE_cfg RSTn REC8 row_fixed
x10 IPG9 MODE_cfgb EN9 net10 clk E9 MODE_cfg RSTn REC9 row_fixed
x11 IPG10 MODE_cfgb EN10 net11 clk E10 MODE_cfg RSTn REC10 row_fixed
x12 IPG11 MODE_cfgb EN11 net12 clk E11 MODE_cfg RSTn REC11 row_fixed
x13 IPG12 MODE_cfgb EN12 net13 clk E12 MODE_cfg RSTn REC12 row_fixed
x14 IPG13 MODE_cfgb EN13 net14 clk E13 MODE_cfg RSTn REC13 row_fixed
x15 IPG14 MODE_cfgb EN14 net15 clk E14 MODE_cfg RSTn REC14 row_fixed
x16 IPG15 MODE_cfgb EN15 net16 clk E15 MODE_cfg RSTn REC15 row_fixed
.ends

* expanding   symbol:  DFF/DFF.sym # of pins=7
** sym_path: /foss/designs/ENGN1600-Project/DFF/DFF.sym
** sch_path: /foss/designs/ENGN1600-Project/DFF/DFF.sch
.subckt DFF vdd RSTn D Q Qb CLK vss
*.PININFO D:I CLK:I RSTn:I Q:O vdd:B vss:B Qb:O
M1 net1 D net3 vss nfet_03v3 L=0.28u W=1u nf=1 m=1
M2 net1 D net2 vdd pfet_03v3 L=0.28u W=1u nf=1 m=1
M3 net2 c vdd vdd pfet_03v3 L=0.28u W=1u nf=1 m=1
M4 net3 cbar vss vss nfet_03v3 L=0.28u W=1u nf=1 m=1
M5 cbar CLK vss vss nfet_03v3 L=0.28u W=1u nf=1 m=1
M6 cbar CLK vdd vdd pfet_03v3 L=0.28u W=1u nf=1 m=1
M7 c cbar vss vss nfet_03v3 L=0.28u W=1u nf=1 m=1
M8 c cbar vdd vdd pfet_03v3 L=0.28u W=1u nf=1 m=1
M11 net5 RSTn net4 vss nfet_03v3 L=0.28u W=1u nf=1 m=1
M12 net4 net6 vss vss nfet_03v3 L=0.28u W=1u nf=1 m=1
M13 net5 RSTn vdd vdd pfet_03v3 L=0.28u W=1u nf=1 m=1
M14 net5 net6 vdd vdd pfet_03v3 L=0.28u W=1u nf=1 m=1
M15 net6 net1 vss vss nfet_03v3 L=0.28u W=1u nf=1 m=1
M16 net6 net1 vdd vdd pfet_03v3 L=0.28u W=1u nf=1 m=1
M21 net9 net7 net8 vss nfet_03v3 L=0.28u W=1u nf=1 m=1
M22 net8 RSTn vss vss nfet_03v3 L=0.28u W=1u nf=1 m=1
M23 net9 net7 vdd vdd pfet_03v3 L=0.28u W=1u nf=1 m=1
M24 net9 RSTn vdd vdd pfet_03v3 L=0.28u W=1u nf=1 m=1
M25 Q net9 vss vss nfet_03v3 L=0.28u W=1u nf=1 m=1
M26 Q net9 vdd vdd pfet_03v3 L=0.28u W=1u nf=1 m=1
M19 net7 net9 net11 vss nfet_03v3 L=0.28u W=1u nf=1 m=1
M20 net7 net9 net10 vdd pfet_03v3 L=0.28u W=1u nf=1 m=1
M31 net10 c vdd vdd pfet_03v3 L=0.28u W=1u nf=1 m=1
M32 net11 cbar vss vss nfet_03v3 L=0.28u W=1u nf=1 m=1
M35 net12 net9 vss vss nfet_03v3 L=0.28u W=1u nf=1 m=1
M36 net12 net9 vdd vdd pfet_03v3 L=0.28u W=1u nf=1 m=1
M37 Qb net12 vss vss nfet_03v3 L=0.28u W=1u nf=1 m=1
M38 Qb net12 vdd vdd pfet_03v3 L=0.28u W=1u nf=1 m=1
M9 net1 c net5 vss nfet_03v3 L=0.28u W=1u nf=1 m=1
M10 net1 cbar net5 vdd pfet_03v3 L=0.28u W=1u nf=1 m=1
M17 net6 c net7 vss nfet_03v3 L=0.28u W=1u nf=1 m=1
M18 net6 cbar net7 vdd pfet_03v3 L=0.28u W=1u nf=1 m=1
.ends

* expanding   symbol:  ENGN1600-Project/row_fixed.sym # of pins=9
** sym_path: /foss/designs/ENGN1600-Project/row_fixed.sym
** sch_path: /foss/designs/ENGN1600-Project/row_fixed.sch
.subckt row_fixed IPG MODEb EN EN_cfgb clk E MODE RSTn REC
*.PININFO EN:I clk:I MODEb:I MODE:I E:I IPG:O REC:O RSTn:I EN_cfgb:O
x1 EN_cfg SW_IPG_pre MODEb AND
x2 vdd RSTn EN EN_cfg EN_cfgb clk GND DFF
x3 IPG SW_IPG SW_IPGb E TGATE
x4 EN_cfg SW_REC_pre MODE AND
x6 REC SW_REC SW_RECb E TGATE
x5 SW_IPGb SW_IPG INV
x7 SW_RECb SW_REC INV
x1b SW_RECb SW_IPG SW_IPG_pre AND
x4b SW_IPGb SW_REC SW_REC_pre AND
.ends

* expanding   symbol:  AND/AND.sym # of pins=3
** sym_path: /foss/designs/ENGN1600-Project/AND/AND.sym
** sch_path: /foss/designs/ENGN1600-Project/AND/AND.sch
.subckt AND IN0 OUT IN1
*.PININFO OUT:O IN0:I IN1:I
M1 net1 IN0 net2 GND nfet_03v3 L=0.28u W=1u nf=1 m=1
M2 net2 IN1 GND GND nfet_03v3 L=0.28u W=1u nf=1 m=1
M3 net1 IN0 vdd vdd pfet_03v3 L=0.28u W=1u nf=1 m=1
M4 net1 IN1 vdd vdd pfet_03v3 L=0.28u W=1u nf=1 m=1
x1 OUT net1 INV
.ends

* expanding   symbol:  TGATE/TGATE.sym # of pins=4
** sym_path: /foss/designs/ENGN1600-Project/TGATE/TGATE.sym
** sch_path: /foss/designs/ENGN1600-Project/TGATE/TGATE.sch
.subckt TGATE out c cbar in
*.PININFO in:I out:O cbar:I c:I
M1 out cbar in VDD pfet_03v3 L=0.28u W=1u nf=1 m=1
M2 out c in GND nfet_03v3 L=0.28u W=1u nf=1 m=1
.ends

* expanding   symbol:  AND/INV.sym # of pins=2
** sym_path: /foss/designs/ENGN1600-Project/AND/INV.sym
** sch_path: /foss/designs/ENGN1600-Project/AND/INV.sch
.subckt INV OUT IN
*.PININFO IN:I OUT:O
M1 OUT IN VDD VDD pfet_03v3 L=0.28u W=1u nf=1 m=1
M2 OUT IN GND GND nfet_03v3 L=0.28u W=0.5u nf=1 m=1
.ends

.GLOBAL GND
.GLOBAL vdd
.GLOBAL VDD
