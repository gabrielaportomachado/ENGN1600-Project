* Extracted by KLayout with GF180MCU LVS runset on : 08/05/2026 02:14

.SUBCKT ROW VDD E REC RSTn EN CLK MODE GND IPG MODEb
M$1 \$8 \$7 VDD VDD pfet_03v3 L=0.28U W=1U AS=0.65P AD=0.42P PS=3.3U PD=1.84U
M$2 VDD \$20 \$8 VDD pfet_03v3 L=0.28U W=1U AS=0.42P AD=0.735P PS=1.84U PD=2.47U
M$3 \$9 \$8 VDD VDD pfet_03v3 L=0.28U W=1U AS=0.735P AD=0.635P PS=2.47U PD=3.27U
M$4 \$10 \$9 VDD VDD pfet_03v3 L=0.28U W=1U AS=0.55P AD=0.65P PS=3.1U PD=3.3U
M$5 REC \$10 E VDD pfet_03v3 L=0.28U W=1U AS=0.65P AD=0.65P PS=3.3U PD=3.3U
M$6 \$3 \$13 VDD VDD pfet_03v3 L=0.28U W=1U AS=0.76P AD=0.65P PS=3.52U PD=3.3U
M$7 VDD \$3 \$4 VDD pfet_03v3 L=0.28U W=1U AS=0.65P AD=0.65P PS=3.3U PD=3.3U
M$8 \$4 RSTn VDD VDD pfet_03v3 L=0.28U W=1U AS=0.65P AD=0.65P PS=3.3U PD=3.3U
M$9 \$13 \$2 \$4 VDD pfet_03v3 L=0.28U W=1U AS=0.65P AD=0.59P PS=3.3U PD=3.18U
M$10 \$5 EN \$13 VDD pfet_03v3 L=0.28U W=1U AS=0.63P AD=0.605P PS=3.26U PD=3.21U
M$11 VDD \$15 \$5 VDD pfet_03v3 L=0.28U W=1U AS=0.63P AD=0.54P PS=3.26U PD=3.08U
M$12 VDD \$2 \$15 VDD pfet_03v3 L=0.28U W=1U AS=0.63P AD=0.64P PS=3.26U PD=3.28U
M$13 VDD CLK \$2 VDD pfet_03v3 L=0.28U W=1U AS=0.65P AD=0.65P PS=3.3U PD=3.3U
M$14 \$6 MODE VDD VDD pfet_03v3 L=0.28U W=1U AS=0.65P AD=0.42P PS=3.3U PD=1.84U
M$15 VDD \$18 \$6 VDD pfet_03v3 L=0.28U W=1U AS=0.42P AD=0.735P PS=1.84U
+ PD=2.47U
M$16 \$7 \$6 VDD VDD pfet_03v3 L=0.28U W=1U AS=0.735P AD=0.64P PS=2.47U PD=3.28U
M$17 \$56 \$54 VDD VDD pfet_03v3 L=0.28U W=1U AS=0.65P AD=0.65P PS=3.3U PD=3.3U
M$18 \$85 \$56 \$54 VDD pfet_03v3 L=0.28U W=1U AS=0.65P AD=0.65P PS=3.3U PD=3.3U
M$19 VDD \$15 \$85 VDD pfet_03v3 L=0.28U W=1U AS=0.65P AD=0.65P PS=3.3U PD=3.3U
M$20 \$18 \$56 VDD VDD pfet_03v3 L=0.28U W=1U AS=0.65P AD=0.65P PS=3.3U PD=3.3U
M$21 \$58 \$56 VDD VDD pfet_03v3 L=0.28U W=1U AS=0.65P AD=0.65P PS=3.3U PD=3.3U
M$22 \$59 \$58 VDD VDD pfet_03v3 L=0.28U W=1U AS=0.65P AD=0.65P PS=3.3U PD=3.3U
M$23 \$60 MODEb VDD VDD pfet_03v3 L=0.28U W=1U AS=0.65P AD=0.42P PS=3.3U
+ PD=1.84U
M$24 VDD \$18 \$60 VDD pfet_03v3 L=0.28U W=1U AS=0.42P AD=0.735P PS=1.84U
+ PD=2.47U
M$25 \$67 \$60 VDD VDD pfet_03v3 L=0.28U W=1U AS=0.735P AD=0.63P PS=2.47U
+ PD=3.26U
M$26 \$54 \$2 \$3 VDD pfet_03v3 L=0.28U W=1U AS=0.65P AD=0.65P PS=3.3U PD=3.3U
M$27 \$56 RSTn VDD VDD pfet_03v3 L=0.28U W=1U AS=0.65P AD=0.65P PS=3.3U PD=3.3U
M$28 \$61 \$67 VDD VDD pfet_03v3 L=0.28U W=1U AS=0.65P AD=0.42P PS=3.3U PD=1.84U
M$29 VDD \$10 \$61 VDD pfet_03v3 L=0.28U W=1U AS=0.42P AD=0.735P PS=1.84U
+ PD=2.47U
M$30 \$68 \$61 VDD VDD pfet_03v3 L=0.28U W=1U AS=0.735P AD=0.63P PS=2.47U
+ PD=3.26U
M$31 \$20 \$68 VDD VDD pfet_03v3 L=0.28U W=1U AS=0.56P AD=0.65P PS=3.12U PD=3.3U
M$32 IPG \$20 E VDD pfet_03v3 L=0.28U W=1U AS=0.65P AD=0.65P PS=3.3U PD=3.3U
M$33 \$9 \$8 GND GND nfet_03v3 L=0.28U W=0.5U AS=0.2425P AD=0.315P PS=1.97U
+ PD=2.26U
M$34 \$10 \$9 GND GND nfet_03v3 L=0.28U W=0.5U AS=0.2825P AD=0.315P PS=2.13U
+ PD=2.26U
M$35 \$7 \$6 GND GND nfet_03v3 L=0.28U W=0.5U AS=0.2425P AD=0.3125P PS=1.97U
+ PD=2.25U
M$36 \$52 \$7 GND GND nfet_03v3 L=0.28U W=1U AS=0.63P AD=0.42P PS=3.26U PD=1.84U
M$37 \$8 \$20 \$52 GND nfet_03v3 L=0.28U W=1U AS=0.42P AD=0.65P PS=1.84U PD=3.3U
M$38 REC \$9 E GND nfet_03v3 L=0.28U W=1U AS=0.63P AD=0.63P PS=3.26U PD=3.26U
M$39 \$3 \$13 GND GND nfet_03v3 L=0.28U W=1U AS=0.76P AD=0.61P PS=3.52U PD=3.22U
M$40 \$34 \$3 GND GND nfet_03v3 L=0.28U W=1U AS=0.61P AD=0.61P PS=3.22U PD=3.22U
M$41 \$4 RSTn \$34 GND nfet_03v3 L=0.28U W=1U AS=0.61P AD=0.61P PS=3.22U
+ PD=3.22U
M$42 \$13 \$15 \$4 GND nfet_03v3 L=0.28U W=1U AS=0.61P AD=0.61P PS=3.22U
+ PD=3.22U
M$43 \$35 EN \$13 GND nfet_03v3 L=0.28U W=1U AS=0.61P AD=0.61P PS=3.22U PD=3.22U
M$44 GND \$2 \$35 GND nfet_03v3 L=0.28U W=1U AS=0.61P AD=0.575P PS=3.22U
+ PD=3.15U
M$45 GND \$2 \$15 GND nfet_03v3 L=0.28U W=1U AS=0.61P AD=0.61P PS=3.22U PD=3.22U
M$46 GND CLK \$2 GND nfet_03v3 L=0.28U W=1U AS=0.63P AD=0.67P PS=3.26U PD=3.34U
M$47 \$47 MODE GND GND nfet_03v3 L=0.28U W=1U AS=0.63P AD=0.42P PS=3.26U
+ PD=1.84U
M$48 \$6 \$18 \$47 GND nfet_03v3 L=0.28U W=1U AS=0.42P AD=0.65P PS=1.84U PD=3.3U
M$49 \$54 \$15 \$3 GND nfet_03v3 L=0.28U W=1U AS=0.715P AD=0.61P PS=3.43U
+ PD=3.22U
M$50 \$55 RSTn GND GND nfet_03v3 L=0.28U W=1U AS=0.61P AD=0.61P PS=3.22U
+ PD=3.22U
M$51 \$56 \$54 \$55 GND nfet_03v3 L=0.28U W=1U AS=0.61P AD=0.61P PS=3.22U
+ PD=3.22U
M$52 \$57 \$56 \$54 GND nfet_03v3 L=0.28U W=1U AS=0.61P AD=0.61P PS=3.22U
+ PD=3.22U
M$53 GND \$2 \$57 GND nfet_03v3 L=0.28U W=1U AS=0.61P AD=0.61P PS=3.22U PD=3.22U
M$54 \$18 \$56 GND GND nfet_03v3 L=0.28U W=1U AS=0.61P AD=0.61P PS=3.22U
+ PD=3.22U
M$55 \$58 \$56 GND GND nfet_03v3 L=0.28U W=1U AS=0.61P AD=0.61P PS=3.22U
+ PD=3.22U
M$56 \$59 \$58 GND GND nfet_03v3 L=0.28U W=1U AS=0.61P AD=0.61P PS=3.22U
+ PD=3.22U
M$57 \$81 MODEb GND GND nfet_03v3 L=0.28U W=1U AS=0.63P AD=0.42P PS=3.26U
+ PD=1.84U
M$58 \$60 \$18 \$81 GND nfet_03v3 L=0.28U W=1U AS=0.42P AD=0.65P PS=1.84U
+ PD=3.3U
M$59 \$67 \$60 GND GND nfet_03v3 L=0.28U W=0.5U AS=0.2425P AD=0.31P PS=1.97U
+ PD=2.24U
M$60 \$82 \$67 GND GND nfet_03v3 L=0.28U W=1U AS=0.63P AD=0.42P PS=3.26U
+ PD=1.84U
M$61 \$61 \$10 \$82 GND nfet_03v3 L=0.28U W=1U AS=0.42P AD=0.65P PS=1.84U
+ PD=3.3U
M$62 \$68 \$61 GND GND nfet_03v3 L=0.28U W=0.5U AS=0.2425P AD=0.3275P PS=1.97U
+ PD=2.31U
M$63 \$20 \$68 GND GND nfet_03v3 L=0.28U W=0.5U AS=0.285P AD=0.315P PS=2.14U
+ PD=2.26U
M$64 IPG \$68 E GND nfet_03v3 L=0.28U W=1U AS=0.63P AD=0.63P PS=3.26U PD=3.26U
.ENDS ROW
