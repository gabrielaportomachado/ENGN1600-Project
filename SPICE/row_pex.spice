* NGSPICE file created from ROW.ext - technology: gf180mcuD

.subckt AND$2 a_n450_n984# a_n912_n1080# a_n1108_n1500# w_n898_n1046# a_n962_n1500#
+ a_n206_n1400# a_n966_n984# a_n359_n1400# a_n1112_n984# a_n719_n907# a_n780_n1500#
+ w_n324_n1046# w_n674_n1046# a_n688_n1202#
X0 a_n719_n907# a_n688_n1202# a_n780_n1500# a_n1108_n1500# nfet_03v3 ad=0.65p pd=3.3u as=0.42p ps=1.84u w=1u l=0.28u
X1 a_n780_n1500# a_n912_n1080# a_n962_n1500# a_n1108_n1500# nfet_03v3 ad=0.42p pd=1.84u as=0.63p ps=3.26u w=1u l=0.28u
X2 a_n1108_n1500# a_n719_n907# a_n359_n1400# a_n1108_n1500# nfet_03v3 ad=0.31p pd=2.24u as=0.2425p ps=1.97u w=0.5u l=0.28u
C0 w_n898_n1046# a_n688_n1202# 0.00418f
C1 a_n962_n1500# a_n719_n907# 0.01277f
C2 a_n780_n1500# a_n962_n1500# 0.00599f
C3 a_n719_n907# a_n1112_n984# 0.00206f
C4 a_n359_n1400# a_n780_n1500# 0.00123f
C5 a_n359_n1400# a_n719_n907# 0.12036f
C6 w_n898_n1046# a_n912_n1080# 0.06384f
C7 a_n688_n1202# a_n912_n1080# 0.03899f
C8 a_n962_n1500# a_n688_n1202# 0.00216f
C9 a_n719_n907# w_n324_n1046# 0.06116f
C10 a_n359_n1400# a_n688_n1202# 0.00215f
C11 a_n962_n1500# a_n912_n1080# 0.01438f
C12 a_n912_n1080# a_n1112_n984# 0
C13 a_n359_n1400# a_n912_n1080# 0
C14 a_n719_n907# w_n674_n1046# 0.02349f
C15 a_n688_n1202# w_n324_n1046# 0.00144f
C16 a_n359_n1400# a_n962_n1500# 0.0074f
C17 a_n780_n1500# a_n719_n907# 0.01043f
C18 a_n688_n1202# w_n674_n1046# 0.04973f
C19 a_n912_n1080# w_n674_n1046# 0.00504f
C20 w_n898_n1046# a_n719_n907# 0.00889f
C21 a_n688_n1202# a_n719_n907# 0.13145f
C22 a_n780_n1500# a_n688_n1202# 0.0047f
C23 a_n719_n907# a_n912_n1080# 0.02475f
C24 a_n359_n1400# a_n1108_n1500# 0.10054f
C25 a_n962_n1500# a_n1108_n1500# 0.15217f
C26 a_n719_n907# a_n1108_n1500# 0.73548f
C27 a_n688_n1202# a_n1108_n1500# 0.34773f
C28 a_n1112_n984# a_n1108_n1500# 0.26053f
C29 a_n912_n1080# a_n1108_n1500# 0.38694f
C30 w_n324_n1046# a_n1108_n1500# 0.19084f
C31 w_n674_n1046# a_n1108_n1500# 0.1813f
C32 w_n898_n1046# a_n1108_n1500# 0.18473f
.ends

.subckt AND$3 w_46_265# w_n528_265# a_n742_327# w_n304_265# a_n542_231# a_n318_109#
+ a_n738_n189# a_n592_n189# a_n349_404# a_11_n89# a_n410_n189#
X0 a_n738_n189# a_n349_404# a_11_n89# a_n738_n189# nfet_03v3 ad=0.315p pd=2.26u as=0.2425p ps=1.97u w=0.5u l=0.28u
X1 a_n410_n189# a_n542_231# a_n592_n189# a_n738_n189# nfet_03v3 ad=0.42p pd=1.84u as=0.63p ps=3.26u w=1u l=0.28u
X2 a_n349_404# a_n318_109# a_n410_n189# a_n738_n189# nfet_03v3 ad=0.65p pd=3.3u as=0.42p ps=1.84u w=1u l=0.28u
C0 a_n742_327# a_n542_231# 0
C1 a_n318_109# w_46_265# 0.00144f
C2 a_n542_231# a_11_n89# 0
C3 a_n318_109# a_11_n89# 0.00215f
C4 a_n349_404# a_n410_n189# 0.01043f
C5 a_n592_n189# a_n542_231# 0.01438f
C6 a_n542_231# w_n304_265# 0.00504f
C7 w_46_265# a_n349_404# 0.06116f
C8 a_n742_327# a_n349_404# 0.00206f
C9 a_n592_n189# a_n318_109# 0.00216f
C10 a_n318_109# w_n304_265# 0.04973f
C11 a_n349_404# a_11_n89# 0.12036f
C12 a_n410_n189# a_11_n89# 0.00123f
C13 a_n592_n189# a_n349_404# 0.01277f
C14 w_n304_265# a_n349_404# 0.02349f
C15 a_n542_231# w_n528_265# 0.06384f
C16 a_n318_109# a_n542_231# 0.03899f
C17 a_n318_109# w_n528_265# 0.00418f
C18 a_n592_n189# a_n410_n189# 0.00599f
C19 a_n542_231# a_n349_404# 0.02475f
C20 a_n349_404# w_n528_265# 0.00889f
C21 a_n318_109# a_n349_404# 0.13145f
C22 a_n592_n189# a_11_n89# 0.0074f
C23 a_n318_109# a_n410_n189# 0.0047f
C24 a_11_n89# a_n738_n189# 0.10054f
C25 a_n592_n189# a_n738_n189# 0.15217f
C26 a_n349_404# a_n738_n189# 0.73548f
C27 a_n318_109# a_n738_n189# 0.34773f
C28 a_n742_327# a_n738_n189# 0.26053f
C29 a_n542_231# a_n738_n189# 0.38694f
C30 w_46_265# a_n738_n189# 0.19084f
C31 w_n304_265# a_n738_n189# 0.1813f
C32 w_n528_265# a_n738_n189# 0.18473f
.ends

* Renamed ROW -> ROW_pex_cell to avoid ngspice case-insensitive clash with
* the wrapper's .subckt row.  Port list extended from the 4 ports Magic
* emits (IPG E REC GND) to the 10 ports klayout-LVS sees as the chip's
* actual interface — the extra 6 nets (VDD, RSTn, EN, CLK, MODE, MODEb)
* are referenced internally by row instances/transistors but Magic doesn't
* promote them to ports on its own.
.subckt ROW_pex_cell IPG E REC GND VDD RSTn EN CLK MODE MODEb
XAND$2_0 GND a_7821_2278# GND GND GND a_9592_2447# GND GND GND AND$2_0/a_n719_n907#
+ AND$2_0/a_n780_n1500# GND GND a_9600_1212# AND$2
XAND$3_0 GND GND GND GND a_7821_1286# a_9600_2649# GND GND AND$3_0/a_n349_404# GND
+ AND$3_0/a_n410_n189# AND$3
X0 a_7821_1286# a_7247_1286# GND.t17 GND.t11 nfet_03v3 ad=0.3125p pd=2.25u as=0.2425p ps=1.97u w=0.5u l=0.28u
X1 GND a_7415_2118# a_7247_1286# GND pfet_03v3 ad=0.735p pd=2.47u as=0.42p ps=1.84u w=1u l=0.28u
X2 a_9600_1212# GND GND GND pfet_03v3 ad=0.65p pd=3.3u as=0.55p ps=3.1u w=1u l=0.28u
X3 a_7415_2118# a_5951_2129# GND.t26 GND.t25 nfet_03v3 ad=0.61p pd=3.22u as=0.61p ps=3.22u w=1u l=0.28u
X4 REC.t1 GND E GND.t46 nfet_03v3 ad=0.63p pd=3.26u as=0.63p ps=3.26u w=1u l=0.28u
X5 a_7247_2694# MODEb GND GND pfet_03v3 ad=0.42p pd=1.84u as=0.65p ps=3.3u w=1u l=0.28u
X6 a_4389_1285# RSTn a_4575_1802# GND.t6 nfet_03v3 ad=0.61p pd=3.22u as=0.61p ps=3.22u w=1u l=0.28u
X7 a_9600_1212# GND GND.t60 GND.t49 nfet_03v3 ad=0.315p pd=2.26u as=0.2825p ps=2.13u w=0.5u l=0.28u
X8 a_5077_2694# a_6316_1670# a_4203_1285# GND pfet_03v3 ad=0.65p pd=3.3u as=0.65p ps=3.3u w=1u l=0.28u
X9 a_5263_2694# a_5951_2129# a_5077_2694# GND pfet_03v3 ad=0.65p pd=3.3u as=0.65p ps=3.3u w=1u l=0.28u
X10 a_7247_1286# a_7415_2118# a_7247_1802# GND.t53 nfet_03v3 ad=0.65p pd=3.3u as=0.42p ps=1.84u w=1u l=0.28u
X11 GND CLK a_6316_1670# GND pfet_03v3 ad=0.65p pd=3.3u as=0.65p ps=3.3u w=1u l=0.28u
X12 a_7247_2694# a_7415_2118# a_7247_2178# GND.t53 nfet_03v3 ad=0.65p pd=3.3u as=0.42p ps=1.84u w=1u l=0.28u
X13 a_4575_1802# a_4203_1285# GND.t10 GND.t9 nfet_03v3 ad=0.61p pd=3.22u as=0.61p ps=3.22u w=1u l=0.28u
X14 a_4203_1285# a_5315_1802# GND GND pfet_03v3 ad=0.65p pd=3.3u as=0.76p ps=3.52u w=1u l=0.28u
X15 a_6379_2178# a_5951_2129# GND GND pfet_03v3 ad=0.65p pd=3.3u as=0.65p ps=3.3u w=1u l=0.28u
X16 GND a_6316_1670# a_6198_1286# GND pfet_03v3 ad=0.64p pd=3.28u as=0.63p ps=3.26u w=1u l=0.28u
X17 a_5315_1802# a_6316_1670# a_4389_1285# GND pfet_03v3 ad=0.59p pd=3.18u as=0.65p ps=3.3u w=1u l=0.28u
X18 a_7247_1286# MODE GND GND pfet_03v3 ad=0.42p pd=1.84u as=0.65p ps=3.3u w=1u l=0.28u
X19 GND.t32 a_6316_1670# a_5675_1802# GND.t31 nfet_03v3 ad=0.575p pd=3.15u as=0.61p ps=3.22u w=1u l=0.28u
X20 GND a_6198_1286# a_5675_1286# GND pfet_03v3 ad=0.54p pd=3.08u as=0.63p ps=3.26u w=1u l=0.28u
X21 GND.t36 CLK a_6316_1670# GND.t35 nfet_03v3 ad=0.67p pd=3.34u as=0.63p ps=3.26u w=1u l=0.28u
X22 a_5951_2129# a_5077_2694# GND GND pfet_03v3 ad=0.65p pd=3.3u as=0.65p ps=3.3u w=1u l=0.28u
X23 a_6751_2178# a_6379_2178# GND.t41 GND.t35 nfet_03v3 ad=0.61p pd=3.22u as=0.61p ps=3.22u w=1u l=0.28u
X24 a_7821_2278# a_7247_2694# GND GND pfet_03v3 ad=0.63p pd=3.26u as=0.735p ps=2.47u w=1u l=0.28u
X25 GND.t30 a_6316_1670# a_6198_1286# GND.t29 nfet_03v3 ad=0.61p pd=3.22u as=0.61p ps=3.22u w=1u l=0.28u
X26 a_7415_2118# a_5951_2129# GND GND pfet_03v3 ad=0.65p pd=3.3u as=0.65p ps=3.3u w=1u l=0.28u
X27 a_5077_2694# a_6198_1286# a_4203_1285# GND.t69 nfet_03v3 ad=0.61p pd=3.22u as=0.715p ps=3.43u w=1u l=0.28u
X28 a_7247_2178# MODEb GND.t63 GND.t56 nfet_03v3 ad=0.42p pd=1.84u as=0.63p ps=3.26u w=1u l=0.28u
X29 a_7247_1802# MODE GND.t57 GND.t56 nfet_03v3 ad=0.42p pd=1.84u as=0.63p ps=3.26u w=1u l=0.28u
X30 a_4389_1285# RSTn GND GND pfet_03v3 ad=0.65p pd=3.3u as=0.65p ps=3.3u w=1u l=0.28u
X31 a_5951_2129# RSTn GND GND pfet_03v3 ad=0.65p pd=3.3u as=0.65p ps=3.3u w=1u l=0.28u
X32 a_9600_2649# GND GND.t50 GND.t49 nfet_03v3 ad=0.315p pd=2.26u as=0.285p ps=2.14u w=0.5u l=0.28u
X33 a_5263_2178# a_5951_2129# a_5077_2694# GND.t20 nfet_03v3 ad=0.61p pd=3.22u as=0.61p ps=3.22u w=1u l=0.28u
X34 a_5315_1802# a_6198_1286# a_4389_1285# GND.t68 nfet_03v3 ad=0.61p pd=3.22u as=0.61p ps=3.22u w=1u l=0.28u
X35 GND a_4203_1285# a_4389_1285# GND pfet_03v3 ad=0.65p pd=3.3u as=0.65p ps=3.3u w=1u l=0.28u
X36 a_5675_1286# EN a_5315_1802# GND pfet_03v3 ad=0.605p pd=3.21u as=0.63p ps=3.26u w=1u l=0.28u
X37 a_7821_2278# a_7247_2694# GND.t12 GND.t11 nfet_03v3 ad=0.31p pd=2.24u as=0.2425p ps=1.97u w=0.5u l=0.28u
X38 GND a_7415_2118# a_7247_2694# GND pfet_03v3 ad=0.735p pd=2.47u as=0.42p ps=1.84u w=1u l=0.28u
X39 a_4518_2178# RSTn GND.t1 GND.t0 nfet_03v3 ad=0.61p pd=3.22u as=0.61p ps=3.22u w=1u l=0.28u
X40 a_6379_2178# a_5951_2129# GND.t19 GND.t18 nfet_03v3 ad=0.61p pd=3.22u as=0.61p ps=3.22u w=1u l=0.28u
X41 a_7821_1286# a_7247_1286# GND GND pfet_03v3 ad=0.64p pd=3.28u as=0.735p ps=2.47u w=1u l=0.28u
X42 IPG.t0 a_9600_2649# E.t0 GND pfet_03v3 ad=0.65p pd=3.3u as=0.65p ps=3.3u w=1u l=0.28u
X43 a_4203_1285# a_5315_1802# GND.t43 GND.t42 nfet_03v3 ad=0.61p pd=3.22u as=0.76p ps=3.52u w=1u l=0.28u
X44 IPG.t1 a_9592_2447# E.t2 GND.t46 nfet_03v3 ad=0.63p pd=3.26u as=0.63p ps=3.26u w=1u l=0.28u
X45 GND a_6198_1286# a_5263_2694# GND pfet_03v3 ad=0.65p pd=3.3u as=0.65p ps=3.3u w=1u l=0.28u
X46 REC.t0 a_9600_1212# E GND pfet_03v3 ad=0.65p pd=3.3u as=0.65p ps=3.3u w=1u l=0.28u
X47 a_5675_1802# EN a_5315_1802# GND.t75 nfet_03v3 ad=0.61p pd=3.22u as=0.61p ps=3.22u w=1u l=0.28u
X48 a_5951_2129# a_5077_2694# a_4518_2178# GND.t72 nfet_03v3 ad=0.61p pd=3.22u as=0.61p ps=3.22u w=1u l=0.28u
X49 GND.t28 a_6316_1670# a_5263_2178# GND.t27 nfet_03v3 ad=0.61p pd=3.22u as=0.61p ps=3.22u w=1u l=0.28u
X50 a_6751_2178# a_6379_2178# GND GND pfet_03v3 ad=0.65p pd=3.3u as=0.65p ps=3.3u w=1u l=0.28u
X51 a_9600_2649# GND GND GND pfet_03v3 ad=0.65p pd=3.3u as=0.56p ps=3.12u w=1u l=0.28u
R0 GND.n20 GND.n8 4261.41
R1 GND.n5 GND.t49 4125.27
R2 GND.t49 GND.t46 1339.06
R3 GND.t35 GND.t29 1293.72
R4 GND.t53 GND.t11 1220.49
R5 GND.t18 GND.t31 1213.52
R6 GND.t25 GND.t75 1157.73
R7 GND.t20 GND.t6 1101.93
R8 GND.t72 GND.t9 1101.93
R9 GND.t0 GND.t42 1098.44
R10 GND.t27 GND.t68 1063.57
R11 GND.t11 GND.n5 934.549
R12 GND.n21 GND.t56 899.678
R13 GND.n21 GND.t35 829.937
R14 GND.t56 GND.t53 781.116
R15 GND.t69 GND.n20 760.193
R16 GND.n8 GND.n7 364.817
R17 GND.n7 GND.n6 233.483
R18 GND.t9 GND.t0 198.767
R19 GND.t6 GND.t72 195.28
R20 GND.t75 GND.t27 191.792
R21 GND.t42 GND.t69 188.305
R22 GND.t68 GND.t20 181.331
R23 GND.t31 GND.t25 83.6915
R24 GND.n1 GND.t50 11.2743
R25 GND.n1 GND.t60 11.2205
R26 GND.n20 GND.n19 10.6627
R27 GND.n3 GND.t17 9.92987
R28 GND.n3 GND.t12 9.92987
R29 GND.n2 GND.t57 9.08387
R30 GND.n2 GND.t63 9.08387
R31 GND.n14 GND.t26 9.06898
R32 GND.n15 GND.t28 9.06898
R33 GND.n17 GND.t1 9.06898
R34 GND.n11 GND.t30 9.01407
R35 GND.n10 GND.t41 9.00732
R36 GND.n12 GND.t19 9.00732
R37 GND.n16 GND.t10 9.00732
R38 GND.n9 GND.t36 9.00732
R39 GND.n19 GND.t43 8.8205
R40 GND.n13 GND.t32 8.78682
R41 GND.n5 GND.n4 5.27747
R42 GND.n22 GND.n21 5.23712
R43 GND.t29 GND.t18 3.48762
R44 GND.n16 GND.n15 1.23311
R45 GND.n4 GND.n1 1.05507
R46 GND.n3 GND.n2 0.59137
R47 GND.n4 GND.n3 0.342891
R48 GND.n18 GND.n17 0.308652
R49 GND.n14 GND.n13 0.227457
R50 GND.n12 GND.n11 0.214739
R51 GND.n10 GND.n9 0.211804
R52 GND.n15 GND.n14 0.167783
R53 GND.n11 GND.n10 0.150174
R54 GND.n2 GND.n0 0.143326
R55 GND.n19 GND.n18 0.142318
R56 GND.n18 GND 0.140391
R57 GND.n13 GND.n12 0.136478
R58 GND.n9 GND.n0 0.128652
R59 GND.n17 GND.n16 0.0572391
R60 GND.n22 GND.n0 0.0335658
R61 GND GND.n22 0.0333645
R62 E E.t2 9.31775
R63 E E.t0 8.56639
R64 REC REC.t1 9.27918
R65 REC REC.t0 8.60496
R66 IPG IPG.t1 9.27918
R67 IPG IPG.t0 8.60496
C0 a_7415_2118# AND$2_0/a_n780_n1500# 0
C1 a_7415_2118# a_7821_1286# 0.00324f
C2 a_7247_1286# MODE 0.01183f
C3 E a_9592_2447# 0.11196f
C4 MODE MODEb 0.01351f
C5 a_4575_1802# a_6198_1286# 0.01339f
C6 a_7415_2118# a_5077_2694# 0.00975f
C7 CLK a_6316_1670# 0.04586f
C8 a_6751_2178# a_6198_1286# 0
C9 a_9600_1212# a_9600_2649# 0.18104f
C10 AND$2_0/a_n719_n907# E 0
C11 a_5951_2129# a_6379_2178# 0.04447f
C12 a_9592_2447# a_7247_2694# -0.00321f
C13 RSTn a_6198_1286# 0.17522f
C14 a_5951_2129# a_7415_2118# 0.1312f
C15 a_7415_2118# a_5675_1802# 0
C16 a_7821_2278# a_9600_1212# 0.01644f
C17 a_5263_2178# a_6316_1670# 0.05231f
C18 AND$2_0/a_n719_n907# a_7247_2694# 0
C19 a_7247_1286# a_9600_1212# 0
C20 AND$2_0/a_n719_n907# a_9592_2447# 0.1269f
C21 MODE CLK 0.01125f
C22 a_9600_1212# MODEb 0
C23 EN RSTn 0.00288f
C24 a_4575_1802# a_6316_1670# 0.00764f
C25 a_4518_2178# a_5077_2694# 0.05591f
C26 AND$3_0/a_n410_n189# a_7821_1286# 0.00196f
C27 a_6751_2178# a_6316_1670# 0
C28 AND$2_0/a_n719_n907# AND$2_0/a_n780_n1500# -0
C29 REC a_9600_1212# 0.0903f
C30 a_5951_2129# a_7247_2694# 0
C31 a_4518_2178# a_5951_2129# 0.0298f
C32 EN a_6198_1286# 0.03006f
C33 RSTn a_6316_1670# 0.06835f
C34 a_7247_1802# a_9600_2649# 0.00149f
C35 a_7415_2118# a_9600_2649# 0.00591f
C36 a_5263_2694# a_7415_2118# 0.00146f
C37 a_7821_2278# a_7415_2118# 0.00342f
C38 a_5951_2129# a_5675_1286# 0.0012f
C39 a_5675_1286# a_5675_1802# 0.02357f
C40 a_7247_1286# a_7247_1802# 0.01036f
C41 a_4575_1802# a_4203_1285# 0.01387f
C42 CLK a_5315_1802# 0
C43 a_7247_1286# a_7415_2118# 0.1572f
C44 MODEb a_6379_2178# 0.01125f
C45 a_5951_2129# a_5077_2694# 0.90614f
C46 a_7415_2118# MODEb 0.05726f
C47 a_6198_1286# a_6316_1670# 1.05575f
C48 E a_9600_2649# 0.42177f
C49 a_7247_2178# a_6751_2178# 0.00205f
C50 RSTn a_4203_1285# 0.10462f
C51 a_5263_2178# a_5315_1802# 0.00159f
C52 a_5951_2129# a_5675_1802# 0.00268f
C53 EN a_6316_1670# 0.02588f
C54 a_7247_2694# a_9600_2649# 0
C55 a_9592_2447# a_9600_2649# 0.36682f
C56 a_4389_1285# a_4575_1802# 0.06846f
C57 CLK a_6379_2178# 0.01351f
C58 CLK a_7415_2118# 0.00853f
C59 AND$3_0/a_n410_n189# a_9600_2649# 0.00915f
C60 a_7821_2278# a_7247_2694# 0.11661f
C61 AND$2_0/a_n719_n907# a_9600_2649# 0.01728f
C62 a_7821_2278# a_9592_2447# -0.00388f
C63 a_7247_1286# a_7247_2694# 0.0035f
C64 a_4575_1802# a_5315_1802# 0.00764f
C65 a_4389_1285# RSTn 0.09961f
C66 a_7247_2694# MODEb 0.01183f
C67 a_6198_1286# a_4203_1285# 0.18344f
C68 AND$2_0/a_n780_n1500# a_9600_2649# 0.00122f
C69 a_5263_2178# a_7415_2118# 0.00134f
C70 a_7821_1286# a_9600_2649# 0.01582f
C71 a_7821_2278# AND$2_0/a_n719_n907# 0.02181f
C72 REC E 0.11912f
C73 a_5315_1802# RSTn 0.09977f
C74 a_7821_2278# AND$2_0/a_n780_n1500# 0.00196f
C75 a_7821_2278# a_7821_1286# 0.00921f
C76 a_5263_2694# a_5077_2694# 0.02931f
C77 a_7247_1286# a_7821_1286# 0.11667f
C78 AND$3_0/a_n349_404# a_9600_1212# 0.01806f
C79 REC a_9592_2447# 0
C80 a_4389_1285# a_6198_1286# 0.13561f
C81 MODE a_6316_1670# 0.00282f
C82 a_6751_2178# a_6379_2178# 0.13688f
C83 a_5263_2694# a_5951_2129# 0.01967f
C84 a_6751_2178# a_7415_2118# 0.06468f
C85 IPG a_9600_1212# 0
C86 a_5951_2129# MODEb 0
C87 RSTn a_7415_2118# 0
C88 a_5315_1802# a_6198_1286# 0.1821f
C89 a_4389_1285# EN 0
C90 a_6316_1670# a_4203_1285# 0.31272f
C91 EN a_5315_1802# 0.03131f
C92 a_6198_1286# a_6379_2178# 0.0027f
C93 a_7415_2118# a_6198_1286# 0.05735f
C94 a_4389_1285# a_6316_1670# 0.22897f
C95 a_5263_2178# a_5077_2694# 0.03003f
C96 a_6751_2178# a_7247_2694# 0.02819f
C97 a_7415_2118# AND$3_0/a_n349_404# 0
C98 a_7821_2278# a_9600_2649# 0.00164f
C99 EN a_7415_2118# 0
C100 a_4518_2178# RSTn 0.01022f
C101 a_5263_2178# a_5951_2129# 0.02034f
C102 a_5315_1802# a_6316_1670# 0.27862f
C103 a_7247_1286# a_9600_2649# 0.0052f
C104 a_4575_1802# a_5077_2694# 0
C105 a_7247_2178# a_9600_1212# 0.0014f
C106 a_4389_1285# a_4203_1285# 0.24044f
C107 RSTn a_5077_2694# 0.14366f
C108 a_7247_1802# a_6316_1670# 0
C109 a_6316_1670# a_6379_2178# 0.00255f
C110 a_4518_2178# a_6198_1286# 0.04955f
C111 a_6751_2178# a_5951_2129# 0
C112 a_7415_2118# a_6316_1670# 0.05562f
C113 REC a_9600_2649# 0.00155f
C114 E IPG 0.11912f
C115 RSTn a_5951_2129# 0.0265f
C116 a_5315_1802# a_4203_1285# 0.18927f
C117 RSTn a_5675_1802# 0.00165f
C118 AND$3_0/a_n410_n189# AND$3_0/a_n349_404# -0
C119 a_6198_1286# a_5675_1286# 0.0085f
C120 AND$2_0/a_n719_n907# AND$3_0/a_n349_404# 0.00321f
C121 a_7247_1286# CLK 0.00106f
C122 IPG a_9592_2447# 0.0865f
C123 MODE a_7415_2118# 0.05581f
C124 a_6198_1286# a_5077_2694# 0.26863f
C125 a_5263_2178# a_5263_2694# 0.01052f
C126 AND$3_0/a_n349_404# a_7821_1286# 0.02184f
C127 EN a_5675_1286# 0.00288f
C128 AND$2_0/a_n719_n907# IPG 0
C129 a_4389_1285# a_5315_1802# 0.14441f
C130 a_5951_2129# a_6198_1286# 0.16478f
C131 a_7247_2178# a_7415_2118# 0.01831f
C132 a_6198_1286# a_5675_1802# 0.0541f
C133 a_4518_2178# a_6316_1670# 0.00376f
C134 a_7415_2118# a_9600_1212# 0.01539f
C135 EN a_5951_2129# 0.00212f
C136 EN a_5675_1802# 0.00287f
C137 a_7821_2278# a_6751_2178# 0
C138 a_6316_1670# a_5675_1286# 0.04809f
C139 a_6316_1670# a_7821_1286# 0
C140 a_6751_2178# MODEb 0.00541f
C141 a_6316_1670# a_5077_2694# 0.30745f
C142 E a_9600_1212# 0.42124f
C143 a_5315_1802# a_7415_2118# 0
C144 a_7247_2178# a_7247_2694# 0.01036f
C145 a_4518_2178# a_4203_1285# 0
C146 a_5951_2129# a_6316_1670# 0.21408f
C147 a_6316_1670# a_5675_1802# 0.00477f
C148 a_9600_1212# a_7247_2694# 0.00368f
C149 a_9592_2447# a_9600_1212# 0.07747f
C150 a_5263_2694# a_6198_1286# 0.00457f
C151 AND$3_0/a_n349_404# a_9600_2649# 0.04335f
C152 AND$3_0/a_n410_n189# a_9600_1212# 0.00439f
C153 AND$2_0/a_n719_n907# a_9600_1212# 0.0609f
C154 a_7247_1802# a_7415_2118# 0.01888f
C155 a_7247_1286# a_6198_1286# 0
C156 a_5077_2694# a_4203_1285# 0.12876f
C157 a_6198_1286# MODEb 0
C158 a_7415_2118# a_6379_2178# 0.16075f
C159 IPG a_9600_2649# 0.09107f
C160 a_9600_1212# AND$2_0/a_n780_n1500# 0.01061f
C161 a_9600_1212# a_7821_1286# 0.00149f
C162 a_7247_1286# AND$3_0/a_n349_404# 0
C163 a_5951_2129# a_4203_1285# 0
C164 a_5263_2178# RSTn 0.00166f
C165 a_4389_1285# a_5077_2694# 0
C166 CLK a_6198_1286# 0.00134f
C167 a_5263_2694# a_6316_1670# 0.06194f
C168 a_5315_1802# a_5675_1286# 0.03043f
C169 a_4389_1285# a_5951_2129# 0.00118f
C170 a_4575_1802# RSTn 0.02018f
C171 a_7247_2694# a_6379_2178# 0
C172 a_5315_1802# a_5077_2694# 0.00383f
C173 a_7415_2118# a_7247_2694# 0.1879f
C174 a_9592_2447# a_7415_2118# 0
C175 a_7247_1286# a_6316_1670# 0.02095f
C176 a_5263_2178# a_6198_1286# 0.05172f
C177 MODE a_9600_2649# 0
C178 AND$3_0/a_n410_n189# a_7415_2118# 0
C179 AND$2_0/a_n719_n907# a_7415_2118# 0
C180 a_5315_1802# a_5951_2129# 0.02544f
C181 a_5315_1802# a_5675_1802# 0.03019f
C182 REC GND 0.29539f
C183 E GND 0.35669f
C184 IPG GND 0.20897f
C185 a_5315_1802# GND 1.07404f
C186 a_9600_2649# GND 1.42992f
C187 RSTn GND 1.07712f
C188 a_4203_1285# GND 1.28474f
C189 a_5951_2129# GND 2.29646f
C190 a_9592_2447# GND 0.63046f
C191 a_7415_2118# GND 1.93757f
C192 a_6198_1286# GND 1.82747f
C193 a_6316_1670# GND 3.71117f
C194 m1_n1_n1# GND 0.00158f $ **FLOATING
C195 a_5675_1286# GND 0.12437f
C196 a_7247_1286# GND 0.93514f
C197 a_7247_1802# GND 0.02029f
C198 a_5675_1802# GND 0.16295f
C199 a_4389_1285# GND 0.60196f
C200 a_4575_1802# GND 0.16587f
C201 MODE GND 0.35875f
C202 CLK GND 0.37838f
C203 EN GND 0.36639f
C204 a_7247_2178# GND 0.01967f
C205 a_5263_2178# GND 0.15853f
C206 a_4518_2178# GND 0.16355f
C207 a_6751_2178# GND 0.34219f
C208 a_5263_2694# GND 0.1244f
C209 a_7247_2694# GND 0.92654f
C210 MODEb GND 0.35604f
C211 a_6379_2178# GND 0.80184f
C212 a_5077_2694# GND 0.93629f
C213 AND$3_0/a_n410_n189# GND 0.01212f
C214 AND$3_0/a_n349_404# GND 1.06568f
C215 a_7821_1286# GND 0.80971f
C216 AND$2_0/a_n780_n1500# GND 0.01212f
C217 AND$2_0/a_n719_n907# GND 0.9387f
C218 a_7821_2278# GND 0.81235f
C219 a_9600_1212# GND 1.8057f
.ends
