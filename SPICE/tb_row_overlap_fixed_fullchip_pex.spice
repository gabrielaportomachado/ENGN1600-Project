* tb_row_overlap_fixed_fullchip_pex.spice -- post-PEX overlap test of
* row_fixed by exercising row 0 of the full chip's post-PEX extraction.
*
* Why this exists: the standalone Magic extraction of ROW.gds
* (SPICE/row_pex.spice) failed to identify VDD as a net.  Every pfet
* came out with source/bulk = GND, so the cell never switches and the
* old tb_row_overlap_fixed_pex.spice "passes" only because IPG/REC
* are stuck near 0 V (max V(IPG) = 0.20 V over 1.5 us).
*
* In contrast, full_pex.spice (Magic extraction of FULL.gds) correctly
* identifies VDD via the chip-level power straps.  Each ROW instance
* inside FULL_pex_cell has VDD properly extracted on every pfet.  So
* we drive row 0 of the full chip and probe (IPG0, REC0) to get a
* real post-PEX measurement of the cross-coupled break-before-make fix.
*
* All other rows are held off (EN1..EN15 = 0) so they don't compete
* on the shared MODE bus.  MODEb is generated by the chip's internal
* MODE DFF, with its native Q/Qb skew (no need for a 200 ps PWL).
*
* PASS criterion: overlap_max < 0.3 V across the MODE 0->1 transition.

.include /foss/pdks/gf180mcuD/libs.tech/ngspice/design.ngspice
.lib     /foss/pdks/gf180mcuD/libs.tech/ngspice/sm141064.ngspice typical
.include /foss/designs/ENGN1600-Project/SPICE/full_pex_wrap.spice

* --- supplies ---
V_vdd vdd GND 3.3

* --- digital control sources (PWL set in .control) ---
V_RSTn RSTn_in GND 0
V_clk  CLK_in  GND 0
V_MODE MODE_in GND 0

* --- row 0 enable: latches high so row 0 is the only active channel ---
V_EN0  EN0_in  GND 0

* --- row 1..15 disabled: tie EN low so those switches stay open ---
V_EN1  EN1_in  GND 0
V_EN2  EN2_in  GND 0
V_EN3  EN3_in  GND 0
V_EN4  EN4_in  GND 0
V_EN5  EN5_in  GND 0
V_EN6  EN6_in  GND 0
V_EN7  EN7_in  GND 0
V_EN8  EN8_in  GND 0
V_EN9  EN9_in  GND 0
V_EN10 EN10_in GND 0
V_EN11 EN11_in GND 0
V_EN12 EN12_in GND 0
V_EN13 EN13_in GND 0
V_EN14 EN14_in GND 0
V_EN15 EN15_in GND 0

* --- E0 = 3.0 V DC, all other E inputs grounded (rows are off anyway) ---
V_E0   E0_in   GND DC 3.0
V_E1   E1_in   GND DC 0
V_E2   E2_in   GND DC 0
V_E3   E3_in   GND DC 0
V_E4   E4_in   GND DC 0
V_E5   E5_in   GND DC 0
V_E6   E6_in   GND DC 0
V_E7   E7_in   GND DC 0
V_E8   E8_in   GND DC 0
V_E9   E9_in   GND DC 0
V_E10  E10_in  GND DC 0
V_E11  E11_in  GND DC 0
V_E12  E12_in  GND DC 0
V_E13  E13_in  GND DC 0
V_E14  E14_in  GND DC 0
V_E15  E15_in  GND DC 0

* --- per-row loads on chip outputs (10 k pull-down + 10 f, matches
*     the schematic-level tb_row_overlap_fixed.spice) ---
R_IPG0  IPG0_pin  GND 10k
C_IPG0  IPG0_pin  GND 10f
R_REC0  REC0_pin  GND 10k
C_REC0  REC0_pin  GND 10f
R_IPG1  IPG1_pin  GND 10k
C_IPG1  IPG1_pin  GND 10f
R_REC1  REC1_pin  GND 10k
C_REC1  REC1_pin  GND 10f
R_IPG2  IPG2_pin  GND 10k
C_IPG2  IPG2_pin  GND 10f
R_REC2  REC2_pin  GND 10k
C_REC2  REC2_pin  GND 10f
R_IPG3  IPG3_pin  GND 10k
C_IPG3  IPG3_pin  GND 10f
R_REC3  REC3_pin  GND 10k
C_REC3  REC3_pin  GND 10f
R_IPG4  IPG4_pin  GND 10k
C_IPG4  IPG4_pin  GND 10f
R_REC4  REC4_pin  GND 10k
C_REC4  REC4_pin  GND 10f
R_IPG5  IPG5_pin  GND 10k
C_IPG5  IPG5_pin  GND 10f
R_REC5  REC5_pin  GND 10k
C_REC5  REC5_pin  GND 10f
R_IPG6  IPG6_pin  GND 10k
C_IPG6  IPG6_pin  GND 10f
R_REC6  REC6_pin  GND 10k
C_REC6  REC6_pin  GND 10f
R_IPG7  IPG7_pin  GND 10k
C_IPG7  IPG7_pin  GND 10f
R_REC7  REC7_pin  GND 10k
C_REC7  REC7_pin  GND 10f
R_IPG8  IPG8_pin  GND 10k
C_IPG8  IPG8_pin  GND 10f
R_REC8  REC8_pin  GND 10k
C_REC8  REC8_pin  GND 10f
R_IPG9  IPG9_pin  GND 10k
C_IPG9  IPG9_pin  GND 10f
R_REC9  REC9_pin  GND 10k
C_REC9  REC9_pin  GND 10f
R_IPG10 IPG10_pin GND 10k
C_IPG10 IPG10_pin GND 10f
R_REC10 REC10_pin GND 10k
C_REC10 REC10_pin GND 10f
R_IPG11 IPG11_pin GND 10k
C_IPG11 IPG11_pin GND 10f
R_REC11 REC11_pin GND 10k
C_REC11 REC11_pin GND 10f
R_IPG12 IPG12_pin GND 10k
C_IPG12 IPG12_pin GND 10f
R_REC12 REC12_pin GND 10k
C_REC12 REC12_pin GND 10f
R_IPG13 IPG13_pin GND 10k
C_IPG13 IPG13_pin GND 10f
R_REC13 REC13_pin GND 10k
C_REC13 REC13_pin GND 10f
R_IPG14 IPG14_pin GND 10k
C_IPG14 IPG14_pin GND 10f
R_REC14 REC14_pin GND 10k
C_REC14 REC14_pin GND 10f
R_IPG15 IPG15_pin GND 10k
C_IPG15 IPG15_pin GND 10f
R_REC15 REC15_pin GND 10k
C_REC15 REC15_pin GND 10f

* ============================================================================
*   The DUT: one Xchip instance referencing `full`.
*   Pin order MUST match full.sym's port emission order (matches
*   tb_full_chip_pex.spice and full_pex_wrap.spice).
* ============================================================================
Xchip
+ IPG0_pin  EN0_in  MODE_in CLK_in E0_in  REC0_pin RSTn_in
+ IPG1_pin  EN1_in  E1_in   REC1_pin
+ IPG2_pin  EN2_in  E2_in   REC2_pin
+ IPG3_pin  EN3_in  E3_in   REC3_pin
+ IPG4_pin  EN4_in  E4_in   REC4_pin
+ IPG5_pin  EN5_in  E5_in   REC5_pin
+ IPG6_pin  EN6_in  E6_in   REC6_pin
+ IPG7_pin  EN7_in  E7_in   REC7_pin
+ IPG8_pin  EN8_in  E8_in   REC8_pin
+ IPG9_pin  EN9_in  E9_in   REC9_pin
+ IPG10_pin EN10_in E10_in  REC10_pin
+ IPG11_pin EN11_in E11_in  REC11_pin
+ IPG12_pin EN12_in E12_in  REC12_pin
+ IPG13_pin EN13_in E13_in  REC13_pin
+ IPG14_pin EN14_in E14_in  REC14_pin
+ IPG15_pin EN15_in E15_in  REC15_pin
+ full

.control
save all

* --- bring-up:
*     - RSTn released at 50 ns
*     - EN0 asserted high from t=0; latches into row 0's internal EN-DFF on
*       the next rising clock edge (100 ns)
*     - V_clk is a continuous 50 ns-period clock (matches tb_full_chip_pex)
*       so the chip's top-level MODE DFF resamples MODE_in after it
*       transitions at 1 us
*     - MODE_in flips 0->1 at 1 us; the chip's DFF then drives MODE/MODEb
*       to the rows on the next rising clock edge (with intrinsic Q/Qb skew) ---
alter @V_RSTn[PWL] = [ 0 0    50n 0   50.001n 3.3   10u 3.3 ]
alter @V_EN0[PWL]  = [ 0 3.3  10u 3.3 ]
alter @V_clk = pulse(0 3.3 0 1n 1n 24n 50n)
alter @V_MODE[PWL] = [ 0 0    1u 0    1.0001u 3.3   10u 3.3 ]

tran 10p 1.5u 0 10p

* Use the chip-side load nets (IPG0_pin, REC0_pin) as the overlap probe;
* they're directly on the row 0 outputs.
let overlap_v   = (v(ipg0_pin) + v(rec0_pin) - abs(v(ipg0_pin) - v(rec0_pin))) / 2
let overlap_max = vecmax(overlap_v)

let ipg_max = vecmax(v(ipg0_pin))
let rec_max = vecmax(v(rec0_pin))

echo ""
echo "=== Row 0 overlap test (FIXED, post-PEX from FULL.gds extraction) ==="
echo "max v(IPG0) over sim         = $&ipg_max V"
echo "max v(REC0) over sim         = $&rec_max V"
echo "max( min(v(IPG0), v(REC0)) ) = $&overlap_max V   <-- overlap indicator"
echo ""

if $&overlap_max > 0.3
  echo "FAIL_ROW_OVERLAP_FIXED_FULLCHIP_PEX: overlap_max = $&overlap_max V > 0.3 V"
else
  echo "PASS_ROW_OVERLAP_FIXED_FULLCHIP_PEX: overlap_max = $&overlap_max V (< 0.3 V threshold)"
end

write tb_row_overlap_fixed_fullchip_pex.raw
.endc
.end
