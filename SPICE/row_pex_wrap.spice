* row_pex_wrap.spice -- drop-in replacement for the schematic-level row
* using the post-PEX layout (ROW.gds), which currently contains the
* row_fixed cell (cross-coupled break-before-make fix, 64 transistors).
*
* The Magic-extracted SPICE/row_pex.spice defines `.subckt ROW_pex_cell`
* whose port list does NOT match the schematic-level `.subckt row`:
*
*   ROW_pex_cell (post-PEX, 10 ports after we added the 6 internal-only nets):
*     IPG E REC GND VDD RSTn EN CLK MODE MODEb
*
*   row (schematic, 9 ports):
*     IPG MODEb EN EN_cfgb clk E MODE RSTn REC
*
* This file defines `.subckt row` with the schematic 9 ports and internally
* instantiates ROW_pex_cell, mapping ports across.  vdd is declared global
* so the testbench's V_vdd source reaches the cell's VDD port.
* EN_cfgb is a schematic-level monitor output that the layout doesn't expose;
* it's left as an internal-only net inside the wrapper.

.include /foss/designs/ENGN1600-Project/SPICE/row_pex.spice

.global vdd

.subckt row IPG MODEb EN EN_cfgb clk E MODE RSTn REC
*.PININFO IPG:O MODEb:I EN:I EN_cfgb:O clk:I E:I MODE:I RSTn:I REC:O

* Map row's 9 schematic ports onto ROW_pex_cell's 10 ports.
* Layout port order: IPG E REC GND VDD RSTn EN CLK MODE MODEb
Xpex
+ IPG E REC GND vdd RSTn EN clk MODE MODEb
+ ROW_pex_cell

.ends row
