* Extracted by KLayout with GF180MCU LVS runset on : 30/04/2026 21:22

.SUBCKT ROW VDD MODE SW_REC SW_RECb E REC RSTn EN CLK EN_CFG GND EN_CFGb SW_IPG
+ SW_IPGb IPG MODEb
M$1 \$3 \$5 VDD VDD pfet_03v3 L=0.28U W=1U AS=0.76P AD=0.65P PS=3.52U PD=3.3U
M$2 VDD \$3 \$4 VDD pfet_03v3 L=0.28U W=1U AS=0.65P AD=0.65P PS=3.3U PD=3.3U
M$3 \$4 RSTn VDD VDD pfet_03v3 L=0.28U W=1U AS=0.65P AD=0.65P PS=3.3U PD=3.3U
M$4 \$5 \$2 \$4 VDD pfet_03v3 L=0.28U W=1U AS=0.65P AD=0.59P PS=3.3U PD=3.18U
M$5 \$6 EN \$5 VDD pfet_03v3 L=0.28U W=1U AS=0.63P AD=0.605P PS=3.26U PD=3.21U
M$6 VDD \$7 \$6 VDD pfet_03v3 L=0.28U W=1U AS=0.63P AD=0.54P PS=3.26U PD=3.08U
M$7 VDD \$2 \$7 VDD pfet_03v3 L=0.28U W=1U AS=0.63P AD=0.64P PS=3.26U PD=3.28U
M$8 VDD CLK \$2 VDD pfet_03v3 L=0.28U W=1U AS=0.65P AD=0.65P PS=3.3U PD=3.3U
M$9 \$9 MODE VDD VDD pfet_03v3 L=0.28U W=1U AS=0.65P AD=0.42P PS=3.3U PD=1.84U
M$10 VDD EN_CFG \$9 VDD pfet_03v3 L=0.28U W=1U AS=0.42P AD=0.735P PS=1.84U
+ PD=2.47U
M$11 SW_REC \$9 VDD VDD pfet_03v3 L=0.28U W=1U AS=0.735P AD=0.64P PS=2.47U
+ PD=3.28U
M$12 SW_RECb SW_REC VDD VDD pfet_03v3 L=0.28U W=1U AS=0.55P AD=0.65P PS=3.1U
+ PD=3.3U
M$13 REC SW_RECb E VDD pfet_03v3 L=0.28U W=1U AS=0.65P AD=0.65P PS=3.3U PD=3.3U
M$14 \$69 \$46 VDD VDD pfet_03v3 L=0.28U W=1U AS=0.65P AD=0.65P PS=3.3U PD=3.3U
M$15 \$71 \$69 \$46 VDD pfet_03v3 L=0.28U W=1U AS=0.65P AD=0.65P PS=3.3U PD=3.3U
M$16 VDD \$7 \$71 VDD pfet_03v3 L=0.28U W=1U AS=0.65P AD=0.65P PS=3.3U PD=3.3U
M$17 EN_CFG \$69 VDD VDD pfet_03v3 L=0.28U W=1U AS=0.65P AD=0.65P PS=3.3U
+ PD=3.3U
M$18 \$49 \$69 VDD VDD pfet_03v3 L=0.28U W=1U AS=0.65P AD=0.65P PS=3.3U PD=3.3U
M$19 EN_CFGb \$49 VDD VDD pfet_03v3 L=0.28U W=1U AS=0.65P AD=0.65P PS=3.3U
+ PD=3.3U
M$20 \$51 MODEb VDD VDD pfet_03v3 L=0.28U W=1U AS=0.65P AD=0.42P PS=3.3U
+ PD=1.84U
M$21 VDD EN_CFG \$51 VDD pfet_03v3 L=0.28U W=1U AS=0.42P AD=0.735P PS=1.84U
+ PD=2.47U
M$22 SW_IPG \$51 VDD VDD pfet_03v3 L=0.28U W=1U AS=0.735P AD=0.63P PS=2.47U
+ PD=3.26U
M$23 SW_IPGb SW_IPG VDD VDD pfet_03v3 L=0.28U W=1U AS=0.56P AD=0.65P PS=3.12U
+ PD=3.3U
M$24 IPG SW_IPGb E VDD pfet_03v3 L=0.28U W=1U AS=0.65P AD=0.65P PS=3.3U PD=3.3U
M$25 \$46 \$2 \$3 VDD pfet_03v3 L=0.28U W=1U AS=0.65P AD=0.65P PS=3.3U PD=3.3U
M$26 \$69 RSTn VDD VDD pfet_03v3 L=0.28U W=1U AS=0.65P AD=0.65P PS=3.3U PD=3.3U
M$27 SW_REC \$9 GND GND nfet_03v3 L=0.28U W=0.5U AS=0.2425P AD=0.3125P PS=1.97U
+ PD=2.25U
M$28 SW_RECb SW_REC GND GND nfet_03v3 L=0.28U W=0.5U AS=0.2825P AD=0.315P
+ PS=2.13U PD=2.26U
M$29 \$3 \$5 GND GND nfet_03v3 L=0.28U W=1U AS=0.76P AD=0.61P PS=3.52U PD=3.22U
M$30 \$30 \$3 GND GND nfet_03v3 L=0.28U W=1U AS=0.61P AD=0.61P PS=3.22U PD=3.22U
M$31 \$4 RSTn \$30 GND nfet_03v3 L=0.28U W=1U AS=0.61P AD=0.61P PS=3.22U
+ PD=3.22U
M$32 \$5 \$7 \$4 GND nfet_03v3 L=0.28U W=1U AS=0.61P AD=0.61P PS=3.22U PD=3.22U
M$33 \$31 EN \$5 GND nfet_03v3 L=0.28U W=1U AS=0.61P AD=0.61P PS=3.22U PD=3.22U
M$34 GND \$2 \$31 GND nfet_03v3 L=0.28U W=1U AS=0.61P AD=0.575P PS=3.22U
+ PD=3.15U
M$35 GND \$2 \$7 GND nfet_03v3 L=0.28U W=1U AS=0.61P AD=0.61P PS=3.22U PD=3.22U
M$36 GND CLK \$2 GND nfet_03v3 L=0.28U W=1U AS=0.63P AD=0.67P PS=3.26U PD=3.34U
M$37 \$44 MODE GND GND nfet_03v3 L=0.28U W=1U AS=0.63P AD=0.42P PS=3.26U
+ PD=1.84U
M$38 \$9 EN_CFG \$44 GND nfet_03v3 L=0.28U W=1U AS=0.42P AD=0.65P PS=1.84U
+ PD=3.3U
M$39 REC SW_REC E GND nfet_03v3 L=0.28U W=1U AS=0.63P AD=0.63P PS=3.26U PD=3.26U
M$40 \$46 \$7 \$3 GND nfet_03v3 L=0.28U W=1U AS=0.715P AD=0.61P PS=3.43U
+ PD=3.22U
M$41 \$47 RSTn GND GND nfet_03v3 L=0.28U W=1U AS=0.61P AD=0.61P PS=3.22U
+ PD=3.22U
M$42 \$69 \$46 \$47 GND nfet_03v3 L=0.28U W=1U AS=0.61P AD=0.61P PS=3.22U
+ PD=3.22U
M$43 \$48 \$69 \$46 GND nfet_03v3 L=0.28U W=1U AS=0.61P AD=0.61P PS=3.22U
+ PD=3.22U
M$44 GND \$2 \$48 GND nfet_03v3 L=0.28U W=1U AS=0.61P AD=0.61P PS=3.22U PD=3.22U
M$45 EN_CFG \$69 GND GND nfet_03v3 L=0.28U W=1U AS=0.61P AD=0.61P PS=3.22U
+ PD=3.22U
M$46 \$49 \$69 GND GND nfet_03v3 L=0.28U W=1U AS=0.61P AD=0.61P PS=3.22U
+ PD=3.22U
M$47 EN_CFGb \$49 GND GND nfet_03v3 L=0.28U W=1U AS=0.61P AD=0.61P PS=3.22U
+ PD=3.22U
M$48 \$64 MODEb GND GND nfet_03v3 L=0.28U W=1U AS=0.63P AD=0.42P PS=3.26U
+ PD=1.84U
M$49 \$51 EN_CFG \$64 GND nfet_03v3 L=0.28U W=1U AS=0.42P AD=0.65P PS=1.84U
+ PD=3.3U
M$50 SW_IPG \$51 GND GND nfet_03v3 L=0.28U W=0.5U AS=0.2425P AD=0.31P PS=1.97U
+ PD=2.24U
M$51 SW_IPGb SW_IPG GND GND nfet_03v3 L=0.28U W=0.5U AS=0.285P AD=0.315P
+ PS=2.14U PD=2.26U
M$52 IPG SW_IPG E GND nfet_03v3 L=0.28U W=1U AS=0.63P AD=0.63P PS=3.26U PD=3.26U
.ENDS ROW
