* Extracted by KLayout with GF180MCU LVS runset on : 23/04/2026 01:03

.SUBCKT AND GND VDD OUT IN1 IN0
M$1 \$3 IN0 VDD VDD pfet_03v3 L=0.28U W=1U AS=0.65P AD=0.42P PS=3.3U PD=1.84U
M$2 VDD IN1 \$3 VDD pfet_03v3 L=0.28U W=1U AS=0.42P AD=0.735P PS=1.84U PD=2.47U
M$3 OUT \$3 VDD VDD pfet_03v3 L=0.28U W=1U AS=0.735P AD=0.65P PS=2.47U PD=3.3U
M$4 \$7 IN0 GND GND nfet_03v3 L=0.28U W=1U AS=0.63P AD=0.42P PS=3.26U PD=1.84U
M$5 \$3 IN1 \$7 GND nfet_03v3 L=0.28U W=1U AS=0.42P AD=0.65P PS=1.84U PD=3.3U
M$6 OUT \$3 GND GND nfet_03v3 L=0.28U W=0.5U AS=0.2425P AD=0.315P PS=1.97U
+ PD=2.26U
.ENDS AND
