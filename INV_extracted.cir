* Extracted by KLayout with GF180MCU LVS runset on : 22/04/2026 20:42

.SUBCKT INV GND VDD OUT IN
M$1 OUT IN VDD VDD pfet_03v3 L=0.28U W=1U AS=0.65P AD=0.65P PS=3.3U PD=3.3U
M$2 OUT IN GND GND nfet_03v3 L=0.28U W=0.5U AS=0.325P AD=0.315P PS=2.3U PD=2.26U
.ENDS INV
