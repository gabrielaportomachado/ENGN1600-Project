* Extracted by KLayout with GF180MCU LVS runset on : 24/04/2026 01:35

.SUBCKT DFF VSS RSTn CLK Q Qb VDD D
M$1 \$4 CLK VDD VDD pfet_03v3 L=0.28U W=1U AS=0.65P AD=0.65P PS=3.3U PD=3.3U
M$2 \$5 \$4 VDD VDD pfet_03v3 L=0.28U W=1U AS=0.64P AD=0.63P PS=3.28U PD=3.26U
M$3 \$36 \$5 VDD VDD pfet_03v3 L=0.28U W=1U AS=0.54P AD=0.63P PS=3.08U PD=3.26U
M$4 \$7 D \$36 VDD pfet_03v3 L=0.28U W=1U AS=0.605P AD=0.63P PS=3.21U PD=3.26U
M$5 \$13 \$11 VDD VDD pfet_03v3 L=0.28U W=1U AS=0.65P AD=0.65P PS=3.3U PD=3.3U
M$6 \$37 \$13 \$11 VDD pfet_03v3 L=0.28U W=1U AS=0.65P AD=0.65P PS=3.3U PD=3.3U
M$7 VDD \$5 \$37 VDD pfet_03v3 L=0.28U W=1U AS=0.65P AD=0.65P PS=3.3U PD=3.3U
M$8 \$15 \$13 VDD VDD pfet_03v3 L=0.28U W=1U AS=0.65P AD=0.65P PS=3.3U PD=3.3U
M$9 Q \$13 VDD VDD pfet_03v3 L=0.28U W=1U AS=0.65P AD=0.65P PS=3.3U PD=3.3U
M$10 Qb Q VDD VDD pfet_03v3 L=0.28U W=1U AS=0.65P AD=0.65P PS=3.3U PD=3.3U
M$11 \$8 \$4 \$7 VDD pfet_03v3 L=0.28U W=1U AS=0.59P AD=0.65P PS=3.18U PD=3.3U
M$12 VDD RSTn \$8 VDD pfet_03v3 L=0.28U W=1U AS=0.65P AD=0.65P PS=3.3U PD=3.3U
M$13 \$8 \$10 VDD VDD pfet_03v3 L=0.28U W=1U AS=0.65P AD=0.65P PS=3.3U PD=3.3U
M$14 VDD \$7 \$10 VDD pfet_03v3 L=0.28U W=1U AS=0.65P AD=0.65P PS=3.3U PD=3.3U
M$15 \$11 \$4 \$10 VDD pfet_03v3 L=0.28U W=1U AS=0.65P AD=0.65P PS=3.3U PD=3.3U
M$16 \$13 RSTn VDD VDD pfet_03v3 L=0.28U W=1U AS=0.65P AD=0.65P PS=3.3U PD=3.3U
M$17 \$4 CLK VSS VSS nfet_03v3 L=0.28U W=1U AS=0.61P AD=0.63P PS=3.22U PD=3.26U
M$18 \$5 \$4 VSS VSS nfet_03v3 L=0.28U W=1U AS=0.61P AD=0.61P PS=3.22U PD=3.22U
M$19 \$6 \$4 VSS VSS nfet_03v3 L=0.28U W=1U AS=0.575P AD=0.61P PS=3.15U PD=3.22U
M$20 \$7 D \$6 VSS nfet_03v3 L=0.28U W=1U AS=0.61P AD=0.61P PS=3.22U PD=3.22U
M$21 \$8 \$5 \$7 VSS nfet_03v3 L=0.28U W=1U AS=0.61P AD=0.61P PS=3.22U PD=3.22U
M$22 \$9 RSTn \$8 VSS nfet_03v3 L=0.28U W=1U AS=0.61P AD=0.61P PS=3.22U PD=3.22U
M$23 VSS \$10 \$9 VSS nfet_03v3 L=0.28U W=1U AS=0.61P AD=0.61P PS=3.22U PD=3.22U
M$24 VSS \$7 \$10 VSS nfet_03v3 L=0.28U W=1U AS=0.61P AD=0.61P PS=3.22U PD=3.22U
M$25 \$11 \$5 \$10 VSS nfet_03v3 L=0.28U W=1U AS=0.61P AD=0.61P PS=3.22U
+ PD=3.22U
M$26 \$12 RSTn VSS VSS nfet_03v3 L=0.28U W=1U AS=0.61P AD=0.61P PS=3.22U
+ PD=3.22U
M$27 \$13 \$11 \$12 VSS nfet_03v3 L=0.28U W=1U AS=0.61P AD=0.61P PS=3.22U
+ PD=3.22U
M$28 \$14 \$13 \$11 VSS nfet_03v3 L=0.28U W=1U AS=0.61P AD=0.61P PS=3.22U
+ PD=3.22U
M$29 VSS \$4 \$14 VSS nfet_03v3 L=0.28U W=1U AS=0.61P AD=0.61P PS=3.22U PD=3.22U
M$30 \$15 \$13 VSS VSS nfet_03v3 L=0.28U W=1U AS=0.61P AD=0.61P PS=3.22U
+ PD=3.22U
M$31 Q \$13 VSS VSS nfet_03v3 L=0.28U W=1U AS=0.61P AD=0.61P PS=3.22U PD=3.22U
M$32 Qb Q VSS VSS nfet_03v3 L=0.28U W=1U AS=0.61P AD=0.61P PS=3.22U PD=3.22U
.ENDS DFF
