** sch_path: /foss/designs/project/AND/AND.sch
.subckt AND IN0 OUT IN1
*.PININFO OUT:O IN0:I IN1:I
M1 net1 IN0 net2 GND nfet_03v3 L=0.28u W=1u nf=1 m=1
M2 net2 IN1 GND GND nfet_03v3 L=0.28u W=1u nf=1 m=1
M3 net1 IN0 vdd vdd pfet_03v3 L=0.28u W=1u nf=1 m=1
M4 net1 IN1 vdd vdd pfet_03v3 L=0.28u W=1u nf=1 m=1
x1 OUT net1 INV
.ends

* expanding   symbol:  AND/INV.sym # of pins=2
** sym_path: /foss/designs/project/AND/INV.sym
** sch_path: /foss/designs/project/AND/INV.sch
.subckt INV OUT IN
*.PININFO IN:I OUT:O
M1 OUT IN VDD VDD pfet_03v3 L=0.28u W=1u nf=1 m=1
M2 OUT IN GND GND nfet_03v3 L=0.28u W=0.5u nf=1 m=1
.ends

.GLOBAL GND
.GLOBAL vdd
.GLOBAL VDD
