* Extracted by KLayout with GF180MCU LVS runset on : 08/05/2026 13:20

.SUBCKT FULL VDD E15 REC15 RSTN EN15 CLK GND IPG15 EN14 E14 REC14 IPG14 EN13
+ E13 REC13 IPG13 EN12 E12 REC12 IPG12 EN11 E11 REC11 IPG11 EN10 E10 REC10
+ IPG10 EN9 E9 REC9 IPG9 MODE EN8 E8 REC8 IPG8 EN7 E7 REC7 IPG7 EN6 E6 REC6
+ IPG6 E5 REC5 EN5 IPG5 EN4 E4 REC4 IPG4 E3 REC3 EN3 IPG3 EN2 E2 REC2 IPG2 EN1
+ E1 REC1 IPG1 EN0 E0 REC0 IPG0
M$1 \$8 \$7 VDD VDD pfet_03v3 L=0.28U W=1U AS=0.65P AD=0.42P PS=3.3U PD=1.84U
M$2 VDD \$20 \$8 VDD pfet_03v3 L=0.28U W=1U AS=0.42P AD=0.735P PS=1.84U PD=2.47U
M$3 \$9 \$8 VDD VDD pfet_03v3 L=0.28U W=1U AS=0.735P AD=0.635P PS=2.47U PD=3.27U
M$4 \$10 \$9 VDD VDD pfet_03v3 L=0.28U W=1U AS=0.55P AD=0.65P PS=3.1U PD=3.3U
M$5 REC15 \$10 E15 VDD pfet_03v3 L=0.28U W=1U AS=0.65P AD=0.65P PS=3.3U PD=3.3U
M$6 \$3 \$13 VDD VDD pfet_03v3 L=0.28U W=1U AS=0.76P AD=0.65P PS=3.52U PD=3.3U
M$7 VDD \$3 \$4 VDD pfet_03v3 L=0.28U W=1U AS=0.65P AD=0.65P PS=3.3U PD=3.3U
M$8 \$4 RSTN VDD VDD pfet_03v3 L=0.28U W=1U AS=0.65P AD=0.65P PS=3.3U PD=3.3U
M$9 \$13 \$2 \$4 VDD pfet_03v3 L=0.28U W=1U AS=0.65P AD=0.59P PS=3.3U PD=3.18U
M$10 \$5 EN15 \$13 VDD pfet_03v3 L=0.28U W=1U AS=0.63P AD=0.605P PS=3.26U
+ PD=3.21U
M$11 VDD \$15 \$5 VDD pfet_03v3 L=0.28U W=1U AS=0.63P AD=0.54P PS=3.26U PD=3.08U
M$12 VDD \$2 \$15 VDD pfet_03v3 L=0.28U W=1U AS=0.63P AD=0.64P PS=3.26U PD=3.28U
M$13 VDD CLK \$2 VDD pfet_03v3 L=0.28U W=1U AS=0.65P AD=0.65P PS=3.3U PD=3.3U
M$14 \$6 \$19 VDD VDD pfet_03v3 L=0.28U W=1U AS=0.65P AD=0.42P PS=3.3U PD=1.84U
M$15 VDD \$18 \$6 VDD pfet_03v3 L=0.28U W=1U AS=0.42P AD=0.735P PS=1.84U
+ PD=2.47U
M$16 \$7 \$6 VDD VDD pfet_03v3 L=0.28U W=1U AS=0.735P AD=0.64P PS=2.47U PD=3.28U
M$17 \$51 \$2 \$3 VDD pfet_03v3 L=0.28U W=1U AS=0.65P AD=0.65P PS=3.3U PD=3.3U
M$18 \$53 RSTN VDD VDD pfet_03v3 L=0.28U W=1U AS=0.65P AD=0.65P PS=3.3U PD=3.3U
M$19 \$53 \$51 VDD VDD pfet_03v3 L=0.28U W=1U AS=0.65P AD=0.65P PS=3.3U PD=3.3U
M$20 \$78 \$53 \$51 VDD pfet_03v3 L=0.28U W=1U AS=0.65P AD=0.65P PS=3.3U PD=3.3U
M$21 VDD \$15 \$78 VDD pfet_03v3 L=0.28U W=1U AS=0.65P AD=0.65P PS=3.3U PD=3.3U
M$22 \$18 \$53 VDD VDD pfet_03v3 L=0.28U W=1U AS=0.65P AD=0.65P PS=3.3U PD=3.3U
M$23 \$55 \$53 VDD VDD pfet_03v3 L=0.28U W=1U AS=0.65P AD=0.65P PS=3.3U PD=3.3U
M$24 \$56 \$55 VDD VDD pfet_03v3 L=0.28U W=1U AS=0.65P AD=0.65P PS=3.3U PD=3.3U
M$25 \$57 \$60 VDD VDD pfet_03v3 L=0.28U W=1U AS=0.65P AD=0.42P PS=3.3U PD=1.84U
M$26 VDD \$18 \$57 VDD pfet_03v3 L=0.28U W=1U AS=0.42P AD=0.735P PS=1.84U
+ PD=2.47U
M$27 \$61 \$57 VDD VDD pfet_03v3 L=0.28U W=1U AS=0.735P AD=0.63P PS=2.47U
+ PD=3.26U
M$28 \$58 \$61 VDD VDD pfet_03v3 L=0.28U W=1U AS=0.65P AD=0.42P PS=3.3U PD=1.84U
M$29 VDD \$10 \$58 VDD pfet_03v3 L=0.28U W=1U AS=0.42P AD=0.735P PS=1.84U
+ PD=2.47U
M$30 \$62 \$58 VDD VDD pfet_03v3 L=0.28U W=1U AS=0.735P AD=0.63P PS=2.47U
+ PD=3.26U
M$31 \$20 \$62 VDD VDD pfet_03v3 L=0.28U W=1U AS=0.56P AD=0.65P PS=3.12U PD=3.3U
M$32 IPG15 \$20 E15 VDD pfet_03v3 L=0.28U W=1U AS=0.65P AD=0.65P PS=3.3U PD=3.3U
M$33 \$93 \$92 VDD VDD pfet_03v3 L=0.28U W=1U AS=0.76P AD=0.65P PS=3.52U PD=3.3U
M$34 VDD \$93 \$94 VDD pfet_03v3 L=0.28U W=1U AS=0.65P AD=0.65P PS=3.3U PD=3.3U
M$35 \$94 RSTN VDD VDD pfet_03v3 L=0.28U W=1U AS=0.65P AD=0.65P PS=3.3U PD=3.3U
M$36 \$92 \$91 \$94 VDD pfet_03v3 L=0.28U W=1U AS=0.65P AD=0.59P PS=3.3U
+ PD=3.18U
M$37 \$96 EN14 \$92 VDD pfet_03v3 L=0.28U W=1U AS=0.63P AD=0.605P PS=3.26U
+ PD=3.21U
M$38 VDD \$97 \$96 VDD pfet_03v3 L=0.28U W=1U AS=0.63P AD=0.54P PS=3.26U
+ PD=3.08U
M$39 VDD \$91 \$97 VDD pfet_03v3 L=0.28U W=1U AS=0.63P AD=0.64P PS=3.26U
+ PD=3.28U
M$40 VDD CLK \$91 VDD pfet_03v3 L=0.28U W=1U AS=0.65P AD=0.65P PS=3.3U PD=3.3U
M$41 \$98 \$19 VDD VDD pfet_03v3 L=0.28U W=1U AS=0.65P AD=0.42P PS=3.3U PD=1.84U
M$42 VDD \$99 \$98 VDD pfet_03v3 L=0.28U W=1U AS=0.42P AD=0.735P PS=1.84U
+ PD=2.47U
M$43 \$100 \$98 VDD VDD pfet_03v3 L=0.28U W=1U AS=0.735P AD=0.64P PS=2.47U
+ PD=3.28U
M$44 \$101 \$100 VDD VDD pfet_03v3 L=0.28U W=1U AS=0.65P AD=0.42P PS=3.3U
+ PD=1.84U
M$45 VDD \$102 \$101 VDD pfet_03v3 L=0.28U W=1U AS=0.42P AD=0.735P PS=1.84U
+ PD=2.47U
M$46 \$103 \$101 VDD VDD pfet_03v3 L=0.28U W=1U AS=0.735P AD=0.635P PS=2.47U
+ PD=3.27U
M$47 \$104 \$103 VDD VDD pfet_03v3 L=0.28U W=1U AS=0.55P AD=0.65P PS=3.1U
+ PD=3.3U
M$48 REC14 \$104 E14 VDD pfet_03v3 L=0.28U W=1U AS=0.65P AD=0.65P PS=3.3U
+ PD=3.3U
M$49 \$136 \$91 \$93 VDD pfet_03v3 L=0.28U W=1U AS=0.65P AD=0.65P PS=3.3U
+ PD=3.3U
M$50 \$138 RSTN VDD VDD pfet_03v3 L=0.28U W=1U AS=0.65P AD=0.65P PS=3.3U PD=3.3U
M$51 \$138 \$136 VDD VDD pfet_03v3 L=0.28U W=1U AS=0.65P AD=0.65P PS=3.3U
+ PD=3.3U
M$52 \$162 \$138 \$136 VDD pfet_03v3 L=0.28U W=1U AS=0.65P AD=0.65P PS=3.3U
+ PD=3.3U
M$53 VDD \$97 \$162 VDD pfet_03v3 L=0.28U W=1U AS=0.65P AD=0.65P PS=3.3U PD=3.3U
M$54 \$99 \$138 VDD VDD pfet_03v3 L=0.28U W=1U AS=0.65P AD=0.65P PS=3.3U PD=3.3U
M$55 \$140 \$138 VDD VDD pfet_03v3 L=0.28U W=1U AS=0.65P AD=0.65P PS=3.3U
+ PD=3.3U
M$56 \$141 \$140 VDD VDD pfet_03v3 L=0.28U W=1U AS=0.65P AD=0.65P PS=3.3U
+ PD=3.3U
M$57 \$142 \$60 VDD VDD pfet_03v3 L=0.28U W=1U AS=0.65P AD=0.42P PS=3.3U
+ PD=1.84U
M$58 VDD \$99 \$142 VDD pfet_03v3 L=0.28U W=1U AS=0.42P AD=0.735P PS=1.84U
+ PD=2.47U
M$59 \$143 \$142 VDD VDD pfet_03v3 L=0.28U W=1U AS=0.735P AD=0.63P PS=2.47U
+ PD=3.26U
M$60 \$144 \$143 VDD VDD pfet_03v3 L=0.28U W=1U AS=0.65P AD=0.42P PS=3.3U
+ PD=1.84U
M$61 VDD \$104 \$144 VDD pfet_03v3 L=0.28U W=1U AS=0.42P AD=0.735P PS=1.84U
+ PD=2.47U
M$62 \$145 \$144 VDD VDD pfet_03v3 L=0.28U W=1U AS=0.735P AD=0.63P PS=2.47U
+ PD=3.26U
M$63 \$102 \$145 VDD VDD pfet_03v3 L=0.28U W=1U AS=0.56P AD=0.65P PS=3.12U
+ PD=3.3U
M$64 IPG14 \$102 E14 VDD pfet_03v3 L=0.28U W=1U AS=0.65P AD=0.65P PS=3.3U
+ PD=3.3U
M$65 \$177 \$176 VDD VDD pfet_03v3 L=0.28U W=1U AS=0.76P AD=0.65P PS=3.52U
+ PD=3.3U
M$66 VDD \$177 \$178 VDD pfet_03v3 L=0.28U W=1U AS=0.65P AD=0.65P PS=3.3U
+ PD=3.3U
M$67 \$178 RSTN VDD VDD pfet_03v3 L=0.28U W=1U AS=0.65P AD=0.65P PS=3.3U PD=3.3U
M$68 \$176 \$175 \$178 VDD pfet_03v3 L=0.28U W=1U AS=0.65P AD=0.59P PS=3.3U
+ PD=3.18U
M$69 \$180 EN13 \$176 VDD pfet_03v3 L=0.28U W=1U AS=0.63P AD=0.605P PS=3.26U
+ PD=3.21U
M$70 VDD \$181 \$180 VDD pfet_03v3 L=0.28U W=1U AS=0.63P AD=0.54P PS=3.26U
+ PD=3.08U
M$71 VDD \$175 \$181 VDD pfet_03v3 L=0.28U W=1U AS=0.63P AD=0.64P PS=3.26U
+ PD=3.28U
M$72 VDD CLK \$175 VDD pfet_03v3 L=0.28U W=1U AS=0.65P AD=0.65P PS=3.3U PD=3.3U
M$73 \$182 \$19 VDD VDD pfet_03v3 L=0.28U W=1U AS=0.65P AD=0.42P PS=3.3U
+ PD=1.84U
M$74 VDD \$223 \$182 VDD pfet_03v3 L=0.28U W=1U AS=0.42P AD=0.735P PS=1.84U
+ PD=2.47U
M$75 \$183 \$182 VDD VDD pfet_03v3 L=0.28U W=1U AS=0.735P AD=0.64P PS=2.47U
+ PD=3.28U
M$76 \$184 \$183 VDD VDD pfet_03v3 L=0.28U W=1U AS=0.65P AD=0.42P PS=3.3U
+ PD=1.84U
M$77 VDD \$185 \$184 VDD pfet_03v3 L=0.28U W=1U AS=0.42P AD=0.735P PS=1.84U
+ PD=2.47U
M$78 \$186 \$184 VDD VDD pfet_03v3 L=0.28U W=1U AS=0.735P AD=0.635P PS=2.47U
+ PD=3.27U
M$79 \$187 \$186 VDD VDD pfet_03v3 L=0.28U W=1U AS=0.55P AD=0.65P PS=3.1U
+ PD=3.3U
M$80 REC13 \$187 E13 VDD pfet_03v3 L=0.28U W=1U AS=0.65P AD=0.65P PS=3.3U
+ PD=3.3U
M$81 \$219 \$175 \$177 VDD pfet_03v3 L=0.28U W=1U AS=0.65P AD=0.65P PS=3.3U
+ PD=3.3U
M$82 \$221 RSTN VDD VDD pfet_03v3 L=0.28U W=1U AS=0.65P AD=0.65P PS=3.3U PD=3.3U
M$83 \$221 \$219 VDD VDD pfet_03v3 L=0.28U W=1U AS=0.65P AD=0.65P PS=3.3U
+ PD=3.3U
M$84 \$246 \$221 \$219 VDD pfet_03v3 L=0.28U W=1U AS=0.65P AD=0.65P PS=3.3U
+ PD=3.3U
M$85 VDD \$181 \$246 VDD pfet_03v3 L=0.28U W=1U AS=0.65P AD=0.65P PS=3.3U
+ PD=3.3U
M$86 \$223 \$221 VDD VDD pfet_03v3 L=0.28U W=1U AS=0.65P AD=0.65P PS=3.3U
+ PD=3.3U
M$87 \$224 \$221 VDD VDD pfet_03v3 L=0.28U W=1U AS=0.65P AD=0.65P PS=3.3U
+ PD=3.3U
M$88 \$225 \$224 VDD VDD pfet_03v3 L=0.28U W=1U AS=0.65P AD=0.65P PS=3.3U
+ PD=3.3U
M$89 \$226 \$60 VDD VDD pfet_03v3 L=0.28U W=1U AS=0.65P AD=0.42P PS=3.3U
+ PD=1.84U
M$90 VDD \$223 \$226 VDD pfet_03v3 L=0.28U W=1U AS=0.42P AD=0.735P PS=1.84U
+ PD=2.47U
M$91 \$229 \$226 VDD VDD pfet_03v3 L=0.28U W=1U AS=0.735P AD=0.63P PS=2.47U
+ PD=3.26U
M$92 \$227 \$229 VDD VDD pfet_03v3 L=0.28U W=1U AS=0.65P AD=0.42P PS=3.3U
+ PD=1.84U
M$93 VDD \$187 \$227 VDD pfet_03v3 L=0.28U W=1U AS=0.42P AD=0.735P PS=1.84U
+ PD=2.47U
M$94 \$230 \$227 VDD VDD pfet_03v3 L=0.28U W=1U AS=0.735P AD=0.63P PS=2.47U
+ PD=3.26U
M$95 \$185 \$230 VDD VDD pfet_03v3 L=0.28U W=1U AS=0.56P AD=0.65P PS=3.12U
+ PD=3.3U
M$96 IPG13 \$185 E13 VDD pfet_03v3 L=0.28U W=1U AS=0.65P AD=0.65P PS=3.3U
+ PD=3.3U
M$97 \$261 \$260 VDD VDD pfet_03v3 L=0.28U W=1U AS=0.76P AD=0.65P PS=3.52U
+ PD=3.3U
M$98 VDD \$261 \$262 VDD pfet_03v3 L=0.28U W=1U AS=0.65P AD=0.65P PS=3.3U
+ PD=3.3U
M$99 \$262 RSTN VDD VDD pfet_03v3 L=0.28U W=1U AS=0.65P AD=0.65P PS=3.3U PD=3.3U
M$100 \$260 \$247 \$262 VDD pfet_03v3 L=0.28U W=1U AS=0.65P AD=0.59P PS=3.3U
+ PD=3.18U
M$101 \$264 EN12 \$260 VDD pfet_03v3 L=0.28U W=1U AS=0.63P AD=0.605P PS=3.26U
+ PD=3.21U
M$102 VDD \$265 \$264 VDD pfet_03v3 L=0.28U W=1U AS=0.63P AD=0.54P PS=3.26U
+ PD=3.08U
M$103 VDD \$247 \$265 VDD pfet_03v3 L=0.28U W=1U AS=0.63P AD=0.64P PS=3.26U
+ PD=3.28U
M$104 VDD CLK \$247 VDD pfet_03v3 L=0.28U W=1U AS=0.65P AD=0.65P PS=3.3U PD=3.3U
M$105 \$266 \$19 VDD VDD pfet_03v3 L=0.28U W=1U AS=0.65P AD=0.42P PS=3.3U
+ PD=1.84U
M$106 VDD \$267 \$266 VDD pfet_03v3 L=0.28U W=1U AS=0.42P AD=0.735P PS=1.84U
+ PD=2.47U
M$107 \$268 \$266 VDD VDD pfet_03v3 L=0.28U W=1U AS=0.735P AD=0.64P PS=2.47U
+ PD=3.28U
M$108 \$269 \$268 VDD VDD pfet_03v3 L=0.28U W=1U AS=0.65P AD=0.42P PS=3.3U
+ PD=1.84U
M$109 VDD \$270 \$269 VDD pfet_03v3 L=0.28U W=1U AS=0.42P AD=0.735P PS=1.84U
+ PD=2.47U
M$110 \$271 \$269 VDD VDD pfet_03v3 L=0.28U W=1U AS=0.735P AD=0.635P PS=2.47U
+ PD=3.27U
M$111 \$272 \$271 VDD VDD pfet_03v3 L=0.28U W=1U AS=0.55P AD=0.65P PS=3.1U
+ PD=3.3U
M$112 REC12 \$272 E12 VDD pfet_03v3 L=0.28U W=1U AS=0.65P AD=0.65P PS=3.3U
+ PD=3.3U
M$113 \$304 \$247 \$261 VDD pfet_03v3 L=0.28U W=1U AS=0.65P AD=0.65P PS=3.3U
+ PD=3.3U
M$114 \$306 RSTN VDD VDD pfet_03v3 L=0.28U W=1U AS=0.65P AD=0.65P PS=3.3U
+ PD=3.3U
M$115 \$306 \$304 VDD VDD pfet_03v3 L=0.28U W=1U AS=0.65P AD=0.65P PS=3.3U
+ PD=3.3U
M$116 \$330 \$306 \$304 VDD pfet_03v3 L=0.28U W=1U AS=0.65P AD=0.65P PS=3.3U
+ PD=3.3U
M$117 VDD \$265 \$330 VDD pfet_03v3 L=0.28U W=1U AS=0.65P AD=0.65P PS=3.3U
+ PD=3.3U
M$118 \$267 \$306 VDD VDD pfet_03v3 L=0.28U W=1U AS=0.65P AD=0.65P PS=3.3U
+ PD=3.3U
M$119 \$308 \$306 VDD VDD pfet_03v3 L=0.28U W=1U AS=0.65P AD=0.65P PS=3.3U
+ PD=3.3U
M$120 \$309 \$308 VDD VDD pfet_03v3 L=0.28U W=1U AS=0.65P AD=0.65P PS=3.3U
+ PD=3.3U
M$121 \$310 \$60 VDD VDD pfet_03v3 L=0.28U W=1U AS=0.65P AD=0.42P PS=3.3U
+ PD=1.84U
M$122 VDD \$267 \$310 VDD pfet_03v3 L=0.28U W=1U AS=0.42P AD=0.735P PS=1.84U
+ PD=2.47U
M$123 \$313 \$310 VDD VDD pfet_03v3 L=0.28U W=1U AS=0.735P AD=0.63P PS=2.47U
+ PD=3.26U
M$124 \$311 \$313 VDD VDD pfet_03v3 L=0.28U W=1U AS=0.65P AD=0.42P PS=3.3U
+ PD=1.84U
M$125 VDD \$272 \$311 VDD pfet_03v3 L=0.28U W=1U AS=0.42P AD=0.735P PS=1.84U
+ PD=2.47U
M$126 \$314 \$311 VDD VDD pfet_03v3 L=0.28U W=1U AS=0.735P AD=0.63P PS=2.47U
+ PD=3.26U
M$127 \$270 \$314 VDD VDD pfet_03v3 L=0.28U W=1U AS=0.56P AD=0.65P PS=3.12U
+ PD=3.3U
M$128 IPG12 \$270 E12 VDD pfet_03v3 L=0.28U W=1U AS=0.65P AD=0.65P PS=3.3U
+ PD=3.3U
M$129 \$345 \$344 VDD VDD pfet_03v3 L=0.28U W=1U AS=0.76P AD=0.65P PS=3.52U
+ PD=3.3U
M$130 VDD \$345 \$346 VDD pfet_03v3 L=0.28U W=1U AS=0.65P AD=0.65P PS=3.3U
+ PD=3.3U
M$131 \$346 RSTN VDD VDD pfet_03v3 L=0.28U W=1U AS=0.65P AD=0.65P PS=3.3U
+ PD=3.3U
M$132 \$344 \$331 \$346 VDD pfet_03v3 L=0.28U W=1U AS=0.65P AD=0.59P PS=3.3U
+ PD=3.18U
M$133 \$348 EN11 \$344 VDD pfet_03v3 L=0.28U W=1U AS=0.63P AD=0.605P PS=3.26U
+ PD=3.21U
M$134 VDD \$349 \$348 VDD pfet_03v3 L=0.28U W=1U AS=0.63P AD=0.54P PS=3.26U
+ PD=3.08U
M$135 VDD \$331 \$349 VDD pfet_03v3 L=0.28U W=1U AS=0.63P AD=0.64P PS=3.26U
+ PD=3.28U
M$136 VDD CLK \$331 VDD pfet_03v3 L=0.28U W=1U AS=0.65P AD=0.65P PS=3.3U PD=3.3U
M$137 \$350 \$19 VDD VDD pfet_03v3 L=0.28U W=1U AS=0.65P AD=0.42P PS=3.3U
+ PD=1.84U
M$138 VDD \$391 \$350 VDD pfet_03v3 L=0.28U W=1U AS=0.42P AD=0.735P PS=1.84U
+ PD=2.47U
M$139 \$351 \$350 VDD VDD pfet_03v3 L=0.28U W=1U AS=0.735P AD=0.64P PS=2.47U
+ PD=3.28U
M$140 \$352 \$351 VDD VDD pfet_03v3 L=0.28U W=1U AS=0.65P AD=0.42P PS=3.3U
+ PD=1.84U
M$141 VDD \$353 \$352 VDD pfet_03v3 L=0.28U W=1U AS=0.42P AD=0.735P PS=1.84U
+ PD=2.47U
M$142 \$354 \$352 VDD VDD pfet_03v3 L=0.28U W=1U AS=0.735P AD=0.635P PS=2.47U
+ PD=3.27U
M$143 \$355 \$354 VDD VDD pfet_03v3 L=0.28U W=1U AS=0.55P AD=0.65P PS=3.1U
+ PD=3.3U
M$144 REC11 \$355 E11 VDD pfet_03v3 L=0.28U W=1U AS=0.65P AD=0.65P PS=3.3U
+ PD=3.3U
M$145 \$387 \$331 \$345 VDD pfet_03v3 L=0.28U W=1U AS=0.65P AD=0.65P PS=3.3U
+ PD=3.3U
M$146 \$389 RSTN VDD VDD pfet_03v3 L=0.28U W=1U AS=0.65P AD=0.65P PS=3.3U
+ PD=3.3U
M$147 \$389 \$387 VDD VDD pfet_03v3 L=0.28U W=1U AS=0.65P AD=0.65P PS=3.3U
+ PD=3.3U
M$148 \$414 \$389 \$387 VDD pfet_03v3 L=0.28U W=1U AS=0.65P AD=0.65P PS=3.3U
+ PD=3.3U
M$149 VDD \$349 \$414 VDD pfet_03v3 L=0.28U W=1U AS=0.65P AD=0.65P PS=3.3U
+ PD=3.3U
M$150 \$391 \$389 VDD VDD pfet_03v3 L=0.28U W=1U AS=0.65P AD=0.65P PS=3.3U
+ PD=3.3U
M$151 \$392 \$389 VDD VDD pfet_03v3 L=0.28U W=1U AS=0.65P AD=0.65P PS=3.3U
+ PD=3.3U
M$152 \$393 \$392 VDD VDD pfet_03v3 L=0.28U W=1U AS=0.65P AD=0.65P PS=3.3U
+ PD=3.3U
M$153 \$394 \$60 VDD VDD pfet_03v3 L=0.28U W=1U AS=0.65P AD=0.42P PS=3.3U
+ PD=1.84U
M$154 VDD \$391 \$394 VDD pfet_03v3 L=0.28U W=1U AS=0.42P AD=0.735P PS=1.84U
+ PD=2.47U
M$155 \$397 \$394 VDD VDD pfet_03v3 L=0.28U W=1U AS=0.735P AD=0.63P PS=2.47U
+ PD=3.26U
M$156 \$395 \$397 VDD VDD pfet_03v3 L=0.28U W=1U AS=0.65P AD=0.42P PS=3.3U
+ PD=1.84U
M$157 VDD \$355 \$395 VDD pfet_03v3 L=0.28U W=1U AS=0.42P AD=0.735P PS=1.84U
+ PD=2.47U
M$158 \$398 \$395 VDD VDD pfet_03v3 L=0.28U W=1U AS=0.735P AD=0.63P PS=2.47U
+ PD=3.26U
M$159 \$353 \$398 VDD VDD pfet_03v3 L=0.28U W=1U AS=0.56P AD=0.65P PS=3.12U
+ PD=3.3U
M$160 IPG11 \$353 E11 VDD pfet_03v3 L=0.28U W=1U AS=0.65P AD=0.65P PS=3.3U
+ PD=3.3U
M$161 \$429 \$428 VDD VDD pfet_03v3 L=0.28U W=1U AS=0.76P AD=0.65P PS=3.52U
+ PD=3.3U
M$162 VDD \$429 \$430 VDD pfet_03v3 L=0.28U W=1U AS=0.65P AD=0.65P PS=3.3U
+ PD=3.3U
M$163 \$430 RSTN VDD VDD pfet_03v3 L=0.28U W=1U AS=0.65P AD=0.65P PS=3.3U
+ PD=3.3U
M$164 \$428 \$415 \$430 VDD pfet_03v3 L=0.28U W=1U AS=0.65P AD=0.59P PS=3.3U
+ PD=3.18U
M$165 \$432 EN10 \$428 VDD pfet_03v3 L=0.28U W=1U AS=0.63P AD=0.605P PS=3.26U
+ PD=3.21U
M$166 VDD \$433 \$432 VDD pfet_03v3 L=0.28U W=1U AS=0.63P AD=0.54P PS=3.26U
+ PD=3.08U
M$167 VDD \$415 \$433 VDD pfet_03v3 L=0.28U W=1U AS=0.63P AD=0.64P PS=3.26U
+ PD=3.28U
M$168 VDD CLK \$415 VDD pfet_03v3 L=0.28U W=1U AS=0.65P AD=0.65P PS=3.3U PD=3.3U
M$169 \$434 \$19 VDD VDD pfet_03v3 L=0.28U W=1U AS=0.65P AD=0.42P PS=3.3U
+ PD=1.84U
M$170 VDD \$475 \$434 VDD pfet_03v3 L=0.28U W=1U AS=0.42P AD=0.735P PS=1.84U
+ PD=2.47U
M$171 \$435 \$434 VDD VDD pfet_03v3 L=0.28U W=1U AS=0.735P AD=0.64P PS=2.47U
+ PD=3.28U
M$172 \$436 \$435 VDD VDD pfet_03v3 L=0.28U W=1U AS=0.65P AD=0.42P PS=3.3U
+ PD=1.84U
M$173 VDD \$437 \$436 VDD pfet_03v3 L=0.28U W=1U AS=0.42P AD=0.735P PS=1.84U
+ PD=2.47U
M$174 \$438 \$436 VDD VDD pfet_03v3 L=0.28U W=1U AS=0.735P AD=0.635P PS=2.47U
+ PD=3.27U
M$175 \$439 \$438 VDD VDD pfet_03v3 L=0.28U W=1U AS=0.55P AD=0.65P PS=3.1U
+ PD=3.3U
M$176 REC10 \$439 E10 VDD pfet_03v3 L=0.28U W=1U AS=0.65P AD=0.65P PS=3.3U
+ PD=3.3U
M$177 \$471 \$415 \$429 VDD pfet_03v3 L=0.28U W=1U AS=0.65P AD=0.65P PS=3.3U
+ PD=3.3U
M$178 \$473 RSTN VDD VDD pfet_03v3 L=0.28U W=1U AS=0.65P AD=0.65P PS=3.3U
+ PD=3.3U
M$179 \$473 \$471 VDD VDD pfet_03v3 L=0.28U W=1U AS=0.65P AD=0.65P PS=3.3U
+ PD=3.3U
M$180 \$498 \$473 \$471 VDD pfet_03v3 L=0.28U W=1U AS=0.65P AD=0.65P PS=3.3U
+ PD=3.3U
M$181 VDD \$433 \$498 VDD pfet_03v3 L=0.28U W=1U AS=0.65P AD=0.65P PS=3.3U
+ PD=3.3U
M$182 \$475 \$473 VDD VDD pfet_03v3 L=0.28U W=1U AS=0.65P AD=0.65P PS=3.3U
+ PD=3.3U
M$183 \$476 \$473 VDD VDD pfet_03v3 L=0.28U W=1U AS=0.65P AD=0.65P PS=3.3U
+ PD=3.3U
M$184 \$477 \$476 VDD VDD pfet_03v3 L=0.28U W=1U AS=0.65P AD=0.65P PS=3.3U
+ PD=3.3U
M$185 \$478 \$60 VDD VDD pfet_03v3 L=0.28U W=1U AS=0.65P AD=0.42P PS=3.3U
+ PD=1.84U
M$186 VDD \$475 \$478 VDD pfet_03v3 L=0.28U W=1U AS=0.42P AD=0.735P PS=1.84U
+ PD=2.47U
M$187 \$481 \$478 VDD VDD pfet_03v3 L=0.28U W=1U AS=0.735P AD=0.63P PS=2.47U
+ PD=3.26U
M$188 \$479 \$481 VDD VDD pfet_03v3 L=0.28U W=1U AS=0.65P AD=0.42P PS=3.3U
+ PD=1.84U
M$189 VDD \$439 \$479 VDD pfet_03v3 L=0.28U W=1U AS=0.42P AD=0.735P PS=1.84U
+ PD=2.47U
M$190 \$482 \$479 VDD VDD pfet_03v3 L=0.28U W=1U AS=0.735P AD=0.63P PS=2.47U
+ PD=3.26U
M$191 \$437 \$482 VDD VDD pfet_03v3 L=0.28U W=1U AS=0.56P AD=0.65P PS=3.12U
+ PD=3.3U
M$192 IPG10 \$437 E10 VDD pfet_03v3 L=0.28U W=1U AS=0.65P AD=0.65P PS=3.3U
+ PD=3.3U
M$193 \$513 \$512 VDD VDD pfet_03v3 L=0.28U W=1U AS=0.76P AD=0.65P PS=3.52U
+ PD=3.3U
M$194 VDD \$513 \$514 VDD pfet_03v3 L=0.28U W=1U AS=0.65P AD=0.65P PS=3.3U
+ PD=3.3U
M$195 \$514 RSTN VDD VDD pfet_03v3 L=0.28U W=1U AS=0.65P AD=0.65P PS=3.3U
+ PD=3.3U
M$196 \$512 \$499 \$514 VDD pfet_03v3 L=0.28U W=1U AS=0.65P AD=0.59P PS=3.3U
+ PD=3.18U
M$197 \$516 EN9 \$512 VDD pfet_03v3 L=0.28U W=1U AS=0.63P AD=0.605P PS=3.26U
+ PD=3.21U
M$198 VDD \$517 \$516 VDD pfet_03v3 L=0.28U W=1U AS=0.63P AD=0.54P PS=3.26U
+ PD=3.08U
M$199 VDD \$499 \$517 VDD pfet_03v3 L=0.28U W=1U AS=0.63P AD=0.64P PS=3.26U
+ PD=3.28U
M$200 VDD CLK \$499 VDD pfet_03v3 L=0.28U W=1U AS=0.65P AD=0.65P PS=3.3U PD=3.3U
M$201 \$518 \$19 VDD VDD pfet_03v3 L=0.28U W=1U AS=0.65P AD=0.42P PS=3.3U
+ PD=1.84U
M$202 VDD \$519 \$518 VDD pfet_03v3 L=0.28U W=1U AS=0.42P AD=0.735P PS=1.84U
+ PD=2.47U
M$203 \$520 \$518 VDD VDD pfet_03v3 L=0.28U W=1U AS=0.735P AD=0.64P PS=2.47U
+ PD=3.28U
M$204 \$521 \$520 VDD VDD pfet_03v3 L=0.28U W=1U AS=0.65P AD=0.42P PS=3.3U
+ PD=1.84U
M$205 VDD \$522 \$521 VDD pfet_03v3 L=0.28U W=1U AS=0.42P AD=0.735P PS=1.84U
+ PD=2.47U
M$206 \$523 \$521 VDD VDD pfet_03v3 L=0.28U W=1U AS=0.735P AD=0.635P PS=2.47U
+ PD=3.27U
M$207 \$524 \$523 VDD VDD pfet_03v3 L=0.28U W=1U AS=0.55P AD=0.65P PS=3.1U
+ PD=3.3U
M$208 REC9 \$524 E9 VDD pfet_03v3 L=0.28U W=1U AS=0.65P AD=0.65P PS=3.3U PD=3.3U
M$209 \$565 \$584 VDD VDD pfet_03v3 L=0.28U W=1U AS=0.76P AD=0.65P PS=3.52U
+ PD=3.3U
M$210 VDD \$565 \$566 VDD pfet_03v3 L=0.28U W=1U AS=0.65P AD=0.65P PS=3.3U
+ PD=3.3U
M$211 \$566 RSTN VDD VDD pfet_03v3 L=0.28U W=1U AS=0.65P AD=0.65P PS=3.3U
+ PD=3.3U
M$212 \$584 \$564 \$566 VDD pfet_03v3 L=0.28U W=1U AS=0.65P AD=0.59P PS=3.3U
+ PD=3.18U
M$213 \$585 MODE \$584 VDD pfet_03v3 L=0.28U W=1U AS=0.63P AD=0.605P PS=3.26U
+ PD=3.21U
M$214 VDD \$597 \$585 VDD pfet_03v3 L=0.28U W=1U AS=0.63P AD=0.54P PS=3.26U
+ PD=3.08U
M$215 VDD \$564 \$597 VDD pfet_03v3 L=0.28U W=1U AS=0.63P AD=0.64P PS=3.26U
+ PD=3.28U
M$216 VDD CLK \$564 VDD pfet_03v3 L=0.28U W=1U AS=0.65P AD=0.65P PS=3.3U PD=3.3U
M$217 \$558 \$556 VDD VDD pfet_03v3 L=0.28U W=1U AS=0.65P AD=0.65P PS=3.3U
+ PD=3.3U
M$218 \$586 \$558 \$556 VDD pfet_03v3 L=0.28U W=1U AS=0.65P AD=0.65P PS=3.3U
+ PD=3.3U
M$219 VDD \$517 \$586 VDD pfet_03v3 L=0.28U W=1U AS=0.65P AD=0.65P PS=3.3U
+ PD=3.3U
M$220 \$519 \$558 VDD VDD pfet_03v3 L=0.28U W=1U AS=0.65P AD=0.65P PS=3.3U
+ PD=3.3U
M$221 \$560 \$558 VDD VDD pfet_03v3 L=0.28U W=1U AS=0.65P AD=0.65P PS=3.3U
+ PD=3.3U
M$222 \$561 \$560 VDD VDD pfet_03v3 L=0.28U W=1U AS=0.65P AD=0.65P PS=3.3U
+ PD=3.3U
M$223 \$587 \$60 VDD VDD pfet_03v3 L=0.28U W=1U AS=0.65P AD=0.42P PS=3.3U
+ PD=1.84U
M$224 VDD \$519 \$587 VDD pfet_03v3 L=0.28U W=1U AS=0.42P AD=0.735P PS=1.84U
+ PD=2.47U
M$225 \$567 \$587 VDD VDD pfet_03v3 L=0.28U W=1U AS=0.735P AD=0.63P PS=2.47U
+ PD=3.26U
M$226 \$556 \$499 \$513 VDD pfet_03v3 L=0.28U W=1U AS=0.65P AD=0.65P PS=3.3U
+ PD=3.3U
M$227 \$558 RSTN VDD VDD pfet_03v3 L=0.28U W=1U AS=0.65P AD=0.65P PS=3.3U
+ PD=3.3U
M$228 \$633 \$632 VDD VDD pfet_03v3 L=0.28U W=1U AS=0.65P AD=0.42P PS=3.3U
+ PD=1.84U
M$229 VDD \$649 \$633 VDD pfet_03v3 L=0.28U W=1U AS=0.42P AD=0.735P PS=1.84U
+ PD=2.47U
M$230 \$634 \$633 VDD VDD pfet_03v3 L=0.28U W=1U AS=0.735P AD=0.635P PS=2.47U
+ PD=3.27U
M$231 \$562 \$567 VDD VDD pfet_03v3 L=0.28U W=1U AS=0.65P AD=0.42P PS=3.3U
+ PD=1.84U
M$232 VDD \$524 \$562 VDD pfet_03v3 L=0.28U W=1U AS=0.42P AD=0.735P PS=1.84U
+ PD=2.47U
M$233 \$568 \$562 VDD VDD pfet_03v3 L=0.28U W=1U AS=0.735P AD=0.63P PS=2.47U
+ PD=3.26U
M$234 \$635 \$634 VDD VDD pfet_03v3 L=0.28U W=1U AS=0.55P AD=0.65P PS=3.1U
+ PD=3.3U
M$235 \$522 \$568 VDD VDD pfet_03v3 L=0.28U W=1U AS=0.56P AD=0.65P PS=3.12U
+ PD=3.3U
M$236 REC8 \$635 E8 VDD pfet_03v3 L=0.28U W=1U AS=0.65P AD=0.65P PS=3.3U PD=3.3U
M$237 IPG9 \$522 E9 VDD pfet_03v3 L=0.28U W=1U AS=0.65P AD=0.65P PS=3.3U PD=3.3U
M$238 \$627 \$646 VDD VDD pfet_03v3 L=0.28U W=1U AS=0.76P AD=0.65P PS=3.52U
+ PD=3.3U
M$239 VDD \$627 \$628 VDD pfet_03v3 L=0.28U W=1U AS=0.65P AD=0.65P PS=3.3U
+ PD=3.3U
M$240 \$628 RSTN VDD VDD pfet_03v3 L=0.28U W=1U AS=0.65P AD=0.65P PS=3.3U
+ PD=3.3U
M$241 \$646 \$626 \$628 VDD pfet_03v3 L=0.28U W=1U AS=0.65P AD=0.59P PS=3.3U
+ PD=3.18U
M$242 \$630 EN8 \$646 VDD pfet_03v3 L=0.28U W=1U AS=0.63P AD=0.605P PS=3.26U
+ PD=3.21U
M$243 VDD \$647 \$630 VDD pfet_03v3 L=0.28U W=1U AS=0.63P AD=0.54P PS=3.26U
+ PD=3.08U
M$244 VDD \$626 \$647 VDD pfet_03v3 L=0.28U W=1U AS=0.63P AD=0.64P PS=3.26U
+ PD=3.28U
M$245 VDD CLK \$626 VDD pfet_03v3 L=0.28U W=1U AS=0.65P AD=0.65P PS=3.3U PD=3.3U
M$246 \$631 \$19 VDD VDD pfet_03v3 L=0.28U W=1U AS=0.65P AD=0.42P PS=3.3U
+ PD=1.84U
M$247 VDD \$648 \$631 VDD pfet_03v3 L=0.28U W=1U AS=0.42P AD=0.735P PS=1.84U
+ PD=2.47U
M$248 \$632 \$631 VDD VDD pfet_03v3 L=0.28U W=1U AS=0.735P AD=0.64P PS=2.47U
+ PD=3.28U
M$249 \$621 \$564 \$565 VDD pfet_03v3 L=0.28U W=1U AS=0.65P AD=0.65P PS=3.3U
+ PD=3.3U
M$250 \$623 RSTN VDD VDD pfet_03v3 L=0.28U W=1U AS=0.65P AD=0.65P PS=3.3U
+ PD=3.3U
M$251 \$623 \$621 VDD VDD pfet_03v3 L=0.28U W=1U AS=0.65P AD=0.65P PS=3.3U
+ PD=3.3U
M$252 \$662 \$623 \$621 VDD pfet_03v3 L=0.28U W=1U AS=0.65P AD=0.65P PS=3.3U
+ PD=3.3U
M$253 VDD \$597 \$662 VDD pfet_03v3 L=0.28U W=1U AS=0.65P AD=0.65P PS=3.3U
+ PD=3.3U
M$254 \$19 \$623 VDD VDD pfet_03v3 L=0.28U W=1U AS=0.65P AD=0.65P PS=3.3U
+ PD=3.3U
M$255 \$625 \$623 VDD VDD pfet_03v3 L=0.28U W=1U AS=0.65P AD=0.65P PS=3.3U
+ PD=3.3U
M$256 \$60 \$625 VDD VDD pfet_03v3 L=0.28U W=1U AS=0.65P AD=0.65P PS=3.3U
+ PD=3.3U
M$257 \$677 \$675 VDD VDD pfet_03v3 L=0.28U W=1U AS=0.65P AD=0.65P PS=3.3U
+ PD=3.3U
M$258 \$715 \$677 \$675 VDD pfet_03v3 L=0.28U W=1U AS=0.65P AD=0.65P PS=3.3U
+ PD=3.3U
M$259 VDD \$647 \$715 VDD pfet_03v3 L=0.28U W=1U AS=0.65P AD=0.65P PS=3.3U
+ PD=3.3U
M$260 \$648 \$677 VDD VDD pfet_03v3 L=0.28U W=1U AS=0.65P AD=0.65P PS=3.3U
+ PD=3.3U
M$261 \$679 \$677 VDD VDD pfet_03v3 L=0.28U W=1U AS=0.65P AD=0.65P PS=3.3U
+ PD=3.3U
M$262 \$680 \$679 VDD VDD pfet_03v3 L=0.28U W=1U AS=0.65P AD=0.65P PS=3.3U
+ PD=3.3U
M$263 \$681 \$60 VDD VDD pfet_03v3 L=0.28U W=1U AS=0.65P AD=0.42P PS=3.3U
+ PD=1.84U
M$264 VDD \$648 \$681 VDD pfet_03v3 L=0.28U W=1U AS=0.42P AD=0.735P PS=1.84U
+ PD=2.47U
M$265 \$698 \$681 VDD VDD pfet_03v3 L=0.28U W=1U AS=0.735P AD=0.63P PS=2.47U
+ PD=3.26U
M$266 \$675 \$626 \$627 VDD pfet_03v3 L=0.28U W=1U AS=0.65P AD=0.65P PS=3.3U
+ PD=3.3U
M$267 \$677 RSTN VDD VDD pfet_03v3 L=0.28U W=1U AS=0.65P AD=0.65P PS=3.3U
+ PD=3.3U
M$268 \$682 \$698 VDD VDD pfet_03v3 L=0.28U W=1U AS=0.65P AD=0.42P PS=3.3U
+ PD=1.84U
M$269 VDD \$635 \$682 VDD pfet_03v3 L=0.28U W=1U AS=0.42P AD=0.735P PS=1.84U
+ PD=2.47U
M$270 \$699 \$682 VDD VDD pfet_03v3 L=0.28U W=1U AS=0.735P AD=0.63P PS=2.47U
+ PD=3.26U
M$271 \$737 \$736 VDD VDD pfet_03v3 L=0.28U W=1U AS=0.65P AD=0.42P PS=3.3U
+ PD=1.84U
M$272 VDD \$738 \$737 VDD pfet_03v3 L=0.28U W=1U AS=0.42P AD=0.735P PS=1.84U
+ PD=2.47U
M$273 \$739 \$737 VDD VDD pfet_03v3 L=0.28U W=1U AS=0.735P AD=0.635P PS=2.47U
+ PD=3.27U
M$274 \$649 \$699 VDD VDD pfet_03v3 L=0.28U W=1U AS=0.56P AD=0.65P PS=3.12U
+ PD=3.3U
M$275 \$740 \$739 VDD VDD pfet_03v3 L=0.28U W=1U AS=0.55P AD=0.65P PS=3.1U
+ PD=3.3U
M$276 IPG8 \$649 E8 VDD pfet_03v3 L=0.28U W=1U AS=0.65P AD=0.65P PS=3.3U PD=3.3U
M$277 REC7 \$740 E7 VDD pfet_03v3 L=0.28U W=1U AS=0.65P AD=0.65P PS=3.3U PD=3.3U
M$278 \$730 \$729 VDD VDD pfet_03v3 L=0.28U W=1U AS=0.76P AD=0.65P PS=3.52U
+ PD=3.3U
M$279 VDD \$730 \$731 VDD pfet_03v3 L=0.28U W=1U AS=0.65P AD=0.65P PS=3.3U
+ PD=3.3U
M$280 \$731 RSTN VDD VDD pfet_03v3 L=0.28U W=1U AS=0.65P AD=0.65P PS=3.3U
+ PD=3.3U
M$281 \$729 \$716 \$731 VDD pfet_03v3 L=0.28U W=1U AS=0.65P AD=0.59P PS=3.3U
+ PD=3.18U
M$282 \$733 EN7 \$729 VDD pfet_03v3 L=0.28U W=1U AS=0.63P AD=0.605P PS=3.26U
+ PD=3.21U
M$283 VDD \$734 \$733 VDD pfet_03v3 L=0.28U W=1U AS=0.63P AD=0.54P PS=3.26U
+ PD=3.08U
M$284 VDD \$716 \$734 VDD pfet_03v3 L=0.28U W=1U AS=0.63P AD=0.64P PS=3.26U
+ PD=3.28U
M$285 VDD CLK \$716 VDD pfet_03v3 L=0.28U W=1U AS=0.65P AD=0.65P PS=3.3U PD=3.3U
M$286 \$735 \$19 VDD VDD pfet_03v3 L=0.28U W=1U AS=0.65P AD=0.42P PS=3.3U
+ PD=1.84U
M$287 VDD \$776 \$735 VDD pfet_03v3 L=0.28U W=1U AS=0.42P AD=0.735P PS=1.84U
+ PD=2.47U
M$288 \$736 \$735 VDD VDD pfet_03v3 L=0.28U W=1U AS=0.735P AD=0.64P PS=2.47U
+ PD=3.28U
M$289 \$772 \$716 \$730 VDD pfet_03v3 L=0.28U W=1U AS=0.65P AD=0.65P PS=3.3U
+ PD=3.3U
M$290 \$774 RSTN VDD VDD pfet_03v3 L=0.28U W=1U AS=0.65P AD=0.65P PS=3.3U
+ PD=3.3U
M$291 \$774 \$772 VDD VDD pfet_03v3 L=0.28U W=1U AS=0.65P AD=0.65P PS=3.3U
+ PD=3.3U
M$292 \$799 \$774 \$772 VDD pfet_03v3 L=0.28U W=1U AS=0.65P AD=0.65P PS=3.3U
+ PD=3.3U
M$293 VDD \$734 \$799 VDD pfet_03v3 L=0.28U W=1U AS=0.65P AD=0.65P PS=3.3U
+ PD=3.3U
M$294 \$776 \$774 VDD VDD pfet_03v3 L=0.28U W=1U AS=0.65P AD=0.65P PS=3.3U
+ PD=3.3U
M$295 \$777 \$774 VDD VDD pfet_03v3 L=0.28U W=1U AS=0.65P AD=0.65P PS=3.3U
+ PD=3.3U
M$296 \$778 \$777 VDD VDD pfet_03v3 L=0.28U W=1U AS=0.65P AD=0.65P PS=3.3U
+ PD=3.3U
M$297 \$779 \$60 VDD VDD pfet_03v3 L=0.28U W=1U AS=0.65P AD=0.42P PS=3.3U
+ PD=1.84U
M$298 VDD \$776 \$779 VDD pfet_03v3 L=0.28U W=1U AS=0.42P AD=0.735P PS=1.84U
+ PD=2.47U
M$299 \$782 \$779 VDD VDD pfet_03v3 L=0.28U W=1U AS=0.735P AD=0.63P PS=2.47U
+ PD=3.26U
M$300 \$780 \$782 VDD VDD pfet_03v3 L=0.28U W=1U AS=0.65P AD=0.42P PS=3.3U
+ PD=1.84U
M$301 VDD \$740 \$780 VDD pfet_03v3 L=0.28U W=1U AS=0.42P AD=0.735P PS=1.84U
+ PD=2.47U
M$302 \$783 \$780 VDD VDD pfet_03v3 L=0.28U W=1U AS=0.735P AD=0.63P PS=2.47U
+ PD=3.26U
M$303 \$738 \$783 VDD VDD pfet_03v3 L=0.28U W=1U AS=0.56P AD=0.65P PS=3.12U
+ PD=3.3U
M$304 IPG7 \$738 E7 VDD pfet_03v3 L=0.28U W=1U AS=0.65P AD=0.65P PS=3.3U PD=3.3U
M$305 \$814 \$813 VDD VDD pfet_03v3 L=0.28U W=1U AS=0.76P AD=0.65P PS=3.52U
+ PD=3.3U
M$306 VDD \$814 \$815 VDD pfet_03v3 L=0.28U W=1U AS=0.65P AD=0.65P PS=3.3U
+ PD=3.3U
M$307 \$815 RSTN VDD VDD pfet_03v3 L=0.28U W=1U AS=0.65P AD=0.65P PS=3.3U
+ PD=3.3U
M$308 \$813 \$812 \$815 VDD pfet_03v3 L=0.28U W=1U AS=0.65P AD=0.59P PS=3.3U
+ PD=3.18U
M$309 \$817 EN6 \$813 VDD pfet_03v3 L=0.28U W=1U AS=0.63P AD=0.605P PS=3.26U
+ PD=3.21U
M$310 VDD \$818 \$817 VDD pfet_03v3 L=0.28U W=1U AS=0.63P AD=0.54P PS=3.26U
+ PD=3.08U
M$311 VDD \$812 \$818 VDD pfet_03v3 L=0.28U W=1U AS=0.63P AD=0.64P PS=3.26U
+ PD=3.28U
M$312 VDD CLK \$812 VDD pfet_03v3 L=0.28U W=1U AS=0.65P AD=0.65P PS=3.3U PD=3.3U
M$313 \$819 \$19 VDD VDD pfet_03v3 L=0.28U W=1U AS=0.65P AD=0.42P PS=3.3U
+ PD=1.84U
M$314 VDD \$820 \$819 VDD pfet_03v3 L=0.28U W=1U AS=0.42P AD=0.735P PS=1.84U
+ PD=2.47U
M$315 \$821 \$819 VDD VDD pfet_03v3 L=0.28U W=1U AS=0.735P AD=0.64P PS=2.47U
+ PD=3.28U
M$316 \$822 \$821 VDD VDD pfet_03v3 L=0.28U W=1U AS=0.65P AD=0.42P PS=3.3U
+ PD=1.84U
M$317 VDD \$823 \$822 VDD pfet_03v3 L=0.28U W=1U AS=0.42P AD=0.735P PS=1.84U
+ PD=2.47U
M$318 \$824 \$822 VDD VDD pfet_03v3 L=0.28U W=1U AS=0.735P AD=0.635P PS=2.47U
+ PD=3.27U
M$319 \$825 \$824 VDD VDD pfet_03v3 L=0.28U W=1U AS=0.55P AD=0.65P PS=3.1U
+ PD=3.3U
M$320 REC6 \$825 E6 VDD pfet_03v3 L=0.28U W=1U AS=0.65P AD=0.65P PS=3.3U PD=3.3U
M$321 \$857 \$812 \$814 VDD pfet_03v3 L=0.28U W=1U AS=0.65P AD=0.65P PS=3.3U
+ PD=3.3U
M$322 \$859 RSTN VDD VDD pfet_03v3 L=0.28U W=1U AS=0.65P AD=0.65P PS=3.3U
+ PD=3.3U
M$323 \$859 \$857 VDD VDD pfet_03v3 L=0.28U W=1U AS=0.65P AD=0.65P PS=3.3U
+ PD=3.3U
M$324 \$883 \$859 \$857 VDD pfet_03v3 L=0.28U W=1U AS=0.65P AD=0.65P PS=3.3U
+ PD=3.3U
M$325 VDD \$818 \$883 VDD pfet_03v3 L=0.28U W=1U AS=0.65P AD=0.65P PS=3.3U
+ PD=3.3U
M$326 \$820 \$859 VDD VDD pfet_03v3 L=0.28U W=1U AS=0.65P AD=0.65P PS=3.3U
+ PD=3.3U
M$327 \$861 \$859 VDD VDD pfet_03v3 L=0.28U W=1U AS=0.65P AD=0.65P PS=3.3U
+ PD=3.3U
M$328 \$862 \$861 VDD VDD pfet_03v3 L=0.28U W=1U AS=0.65P AD=0.65P PS=3.3U
+ PD=3.3U
M$329 \$863 \$60 VDD VDD pfet_03v3 L=0.28U W=1U AS=0.65P AD=0.42P PS=3.3U
+ PD=1.84U
M$330 VDD \$820 \$863 VDD pfet_03v3 L=0.28U W=1U AS=0.42P AD=0.735P PS=1.84U
+ PD=2.47U
M$331 \$864 \$863 VDD VDD pfet_03v3 L=0.28U W=1U AS=0.735P AD=0.63P PS=2.47U
+ PD=3.26U
M$332 \$865 \$864 VDD VDD pfet_03v3 L=0.28U W=1U AS=0.65P AD=0.42P PS=3.3U
+ PD=1.84U
M$333 VDD \$825 \$865 VDD pfet_03v3 L=0.28U W=1U AS=0.42P AD=0.735P PS=1.84U
+ PD=2.47U
M$334 \$866 \$865 VDD VDD pfet_03v3 L=0.28U W=1U AS=0.735P AD=0.63P PS=2.47U
+ PD=3.26U
M$335 \$823 \$866 VDD VDD pfet_03v3 L=0.28U W=1U AS=0.56P AD=0.65P PS=3.12U
+ PD=3.3U
M$336 IPG6 \$823 E6 VDD pfet_03v3 L=0.28U W=1U AS=0.65P AD=0.65P PS=3.3U PD=3.3U
M$337 \$903 \$902 VDD VDD pfet_03v3 L=0.28U W=1U AS=0.76P AD=0.65P PS=3.52U
+ PD=3.3U
M$338 VDD \$903 \$904 VDD pfet_03v3 L=0.28U W=1U AS=0.65P AD=0.65P PS=3.3U
+ PD=3.3U
M$339 \$904 RSTN VDD VDD pfet_03v3 L=0.28U W=1U AS=0.65P AD=0.65P PS=3.3U
+ PD=3.3U
M$340 \$902 \$896 \$904 VDD pfet_03v3 L=0.28U W=1U AS=0.65P AD=0.59P PS=3.3U
+ PD=3.18U
M$341 \$907 EN5 \$902 VDD pfet_03v3 L=0.28U W=1U AS=0.63P AD=0.605P PS=3.26U
+ PD=3.21U
M$342 VDD \$905 \$907 VDD pfet_03v3 L=0.28U W=1U AS=0.63P AD=0.54P PS=3.26U
+ PD=3.08U
M$343 VDD \$896 \$905 VDD pfet_03v3 L=0.28U W=1U AS=0.63P AD=0.64P PS=3.26U
+ PD=3.28U
M$344 VDD CLK \$896 VDD pfet_03v3 L=0.28U W=1U AS=0.65P AD=0.65P PS=3.3U PD=3.3U
M$345 \$909 \$19 VDD VDD pfet_03v3 L=0.28U W=1U AS=0.65P AD=0.42P PS=3.3U
+ PD=1.84U
M$346 VDD \$908 \$909 VDD pfet_03v3 L=0.28U W=1U AS=0.42P AD=0.735P PS=1.84U
+ PD=2.47U
M$347 \$910 \$909 VDD VDD pfet_03v3 L=0.28U W=1U AS=0.735P AD=0.64P PS=2.47U
+ PD=3.28U
M$348 \$897 \$910 VDD VDD pfet_03v3 L=0.28U W=1U AS=0.65P AD=0.42P PS=3.3U
+ PD=1.84U
M$349 VDD \$911 \$897 VDD pfet_03v3 L=0.28U W=1U AS=0.42P AD=0.735P PS=1.84U
+ PD=2.47U
M$350 \$898 \$897 VDD VDD pfet_03v3 L=0.28U W=1U AS=0.735P AD=0.635P PS=2.47U
+ PD=3.27U
M$351 \$899 \$898 VDD VDD pfet_03v3 L=0.28U W=1U AS=0.55P AD=0.65P PS=3.1U
+ PD=3.3U
M$352 REC5 \$899 E5 VDD pfet_03v3 L=0.28U W=1U AS=0.65P AD=0.65P PS=3.3U PD=3.3U
M$353 \$941 \$896 \$903 VDD pfet_03v3 L=0.28U W=1U AS=0.65P AD=0.65P PS=3.3U
+ PD=3.3U
M$354 \$943 RSTN VDD VDD pfet_03v3 L=0.28U W=1U AS=0.65P AD=0.65P PS=3.3U
+ PD=3.3U
M$355 \$943 \$941 VDD VDD pfet_03v3 L=0.28U W=1U AS=0.65P AD=0.65P PS=3.3U
+ PD=3.3U
M$356 \$967 \$943 \$941 VDD pfet_03v3 L=0.28U W=1U AS=0.65P AD=0.65P PS=3.3U
+ PD=3.3U
M$357 VDD \$905 \$967 VDD pfet_03v3 L=0.28U W=1U AS=0.65P AD=0.65P PS=3.3U
+ PD=3.3U
M$358 \$908 \$943 VDD VDD pfet_03v3 L=0.28U W=1U AS=0.65P AD=0.65P PS=3.3U
+ PD=3.3U
M$359 \$945 \$943 VDD VDD pfet_03v3 L=0.28U W=1U AS=0.65P AD=0.65P PS=3.3U
+ PD=3.3U
M$360 \$946 \$945 VDD VDD pfet_03v3 L=0.28U W=1U AS=0.65P AD=0.65P PS=3.3U
+ PD=3.3U
M$361 \$947 \$60 VDD VDD pfet_03v3 L=0.28U W=1U AS=0.65P AD=0.42P PS=3.3U
+ PD=1.84U
M$362 VDD \$908 \$947 VDD pfet_03v3 L=0.28U W=1U AS=0.42P AD=0.735P PS=1.84U
+ PD=2.47U
M$363 \$950 \$947 VDD VDD pfet_03v3 L=0.28U W=1U AS=0.735P AD=0.63P PS=2.47U
+ PD=3.26U
M$364 \$948 \$950 VDD VDD pfet_03v3 L=0.28U W=1U AS=0.65P AD=0.42P PS=3.3U
+ PD=1.84U
M$365 VDD \$899 \$948 VDD pfet_03v3 L=0.28U W=1U AS=0.42P AD=0.735P PS=1.84U
+ PD=2.47U
M$366 \$951 \$948 VDD VDD pfet_03v3 L=0.28U W=1U AS=0.735P AD=0.63P PS=2.47U
+ PD=3.26U
M$367 \$911 \$951 VDD VDD pfet_03v3 L=0.28U W=1U AS=0.56P AD=0.65P PS=3.12U
+ PD=3.3U
M$368 IPG5 \$911 E5 VDD pfet_03v3 L=0.28U W=1U AS=0.65P AD=0.65P PS=3.3U PD=3.3U
M$369 \$983 \$982 VDD VDD pfet_03v3 L=0.28U W=1U AS=0.76P AD=0.65P PS=3.52U
+ PD=3.3U
M$370 VDD \$983 \$984 VDD pfet_03v3 L=0.28U W=1U AS=0.65P AD=0.65P PS=3.3U
+ PD=3.3U
M$371 \$984 RSTN VDD VDD pfet_03v3 L=0.28U W=1U AS=0.65P AD=0.65P PS=3.3U
+ PD=3.3U
M$372 \$982 \$981 \$984 VDD pfet_03v3 L=0.28U W=1U AS=0.65P AD=0.59P PS=3.3U
+ PD=3.18U
M$373 \$985 EN4 \$982 VDD pfet_03v3 L=0.28U W=1U AS=0.63P AD=0.605P PS=3.26U
+ PD=3.21U
M$374 VDD \$986 \$985 VDD pfet_03v3 L=0.28U W=1U AS=0.63P AD=0.54P PS=3.26U
+ PD=3.08U
M$375 VDD \$981 \$986 VDD pfet_03v3 L=0.28U W=1U AS=0.63P AD=0.64P PS=3.26U
+ PD=3.28U
M$376 VDD CLK \$981 VDD pfet_03v3 L=0.28U W=1U AS=0.65P AD=0.65P PS=3.3U PD=3.3U
M$377 \$987 \$19 VDD VDD pfet_03v3 L=0.28U W=1U AS=0.65P AD=0.42P PS=3.3U
+ PD=1.84U
M$378 VDD \$1028 \$987 VDD pfet_03v3 L=0.28U W=1U AS=0.42P AD=0.735P PS=1.84U
+ PD=2.47U
M$379 \$988 \$987 VDD VDD pfet_03v3 L=0.28U W=1U AS=0.735P AD=0.64P PS=2.47U
+ PD=3.28U
M$380 \$989 \$988 VDD VDD pfet_03v3 L=0.28U W=1U AS=0.65P AD=0.42P PS=3.3U
+ PD=1.84U
M$381 VDD \$990 \$989 VDD pfet_03v3 L=0.28U W=1U AS=0.42P AD=0.735P PS=1.84U
+ PD=2.47U
M$382 \$991 \$989 VDD VDD pfet_03v3 L=0.28U W=1U AS=0.735P AD=0.635P PS=2.47U
+ PD=3.27U
M$383 \$992 \$991 VDD VDD pfet_03v3 L=0.28U W=1U AS=0.55P AD=0.65P PS=3.1U
+ PD=3.3U
M$384 REC4 \$992 E4 VDD pfet_03v3 L=0.28U W=1U AS=0.65P AD=0.65P PS=3.3U PD=3.3U
M$385 \$1024 \$981 \$983 VDD pfet_03v3 L=0.28U W=1U AS=0.65P AD=0.65P PS=3.3U
+ PD=3.3U
M$386 \$1026 RSTN VDD VDD pfet_03v3 L=0.28U W=1U AS=0.65P AD=0.65P PS=3.3U
+ PD=3.3U
M$387 \$1026 \$1024 VDD VDD pfet_03v3 L=0.28U W=1U AS=0.65P AD=0.65P PS=3.3U
+ PD=3.3U
M$388 \$1051 \$1026 \$1024 VDD pfet_03v3 L=0.28U W=1U AS=0.65P AD=0.65P PS=3.3U
+ PD=3.3U
M$389 VDD \$986 \$1051 VDD pfet_03v3 L=0.28U W=1U AS=0.65P AD=0.65P PS=3.3U
+ PD=3.3U
M$390 \$1028 \$1026 VDD VDD pfet_03v3 L=0.28U W=1U AS=0.65P AD=0.65P PS=3.3U
+ PD=3.3U
M$391 \$1029 \$1026 VDD VDD pfet_03v3 L=0.28U W=1U AS=0.65P AD=0.65P PS=3.3U
+ PD=3.3U
M$392 \$1030 \$1029 VDD VDD pfet_03v3 L=0.28U W=1U AS=0.65P AD=0.65P PS=3.3U
+ PD=3.3U
M$393 \$1031 \$60 VDD VDD pfet_03v3 L=0.28U W=1U AS=0.65P AD=0.42P PS=3.3U
+ PD=1.84U
M$394 VDD \$1028 \$1031 VDD pfet_03v3 L=0.28U W=1U AS=0.42P AD=0.735P PS=1.84U
+ PD=2.47U
M$395 \$1032 \$1031 VDD VDD pfet_03v3 L=0.28U W=1U AS=0.735P AD=0.63P PS=2.47U
+ PD=3.26U
M$396 \$1033 \$1032 VDD VDD pfet_03v3 L=0.28U W=1U AS=0.65P AD=0.42P PS=3.3U
+ PD=1.84U
M$397 VDD \$992 \$1033 VDD pfet_03v3 L=0.28U W=1U AS=0.42P AD=0.735P PS=1.84U
+ PD=2.47U
M$398 \$1034 \$1033 VDD VDD pfet_03v3 L=0.28U W=1U AS=0.735P AD=0.63P PS=2.47U
+ PD=3.26U
M$399 \$990 \$1034 VDD VDD pfet_03v3 L=0.28U W=1U AS=0.56P AD=0.65P PS=3.12U
+ PD=3.3U
M$400 IPG4 \$990 E4 VDD pfet_03v3 L=0.28U W=1U AS=0.65P AD=0.65P PS=3.3U PD=3.3U
M$401 \$1071 \$1070 VDD VDD pfet_03v3 L=0.28U W=1U AS=0.76P AD=0.65P PS=3.52U
+ PD=3.3U
M$402 VDD \$1071 \$1072 VDD pfet_03v3 L=0.28U W=1U AS=0.65P AD=0.65P PS=3.3U
+ PD=3.3U
M$403 \$1072 RSTN VDD VDD pfet_03v3 L=0.28U W=1U AS=0.65P AD=0.65P PS=3.3U
+ PD=3.3U
M$404 \$1070 \$1064 \$1072 VDD pfet_03v3 L=0.28U W=1U AS=0.65P AD=0.59P PS=3.3U
+ PD=3.18U
M$405 \$1075 EN3 \$1070 VDD pfet_03v3 L=0.28U W=1U AS=0.63P AD=0.605P PS=3.26U
+ PD=3.21U
M$406 VDD \$1073 \$1075 VDD pfet_03v3 L=0.28U W=1U AS=0.63P AD=0.54P PS=3.26U
+ PD=3.08U
M$407 VDD \$1064 \$1073 VDD pfet_03v3 L=0.28U W=1U AS=0.63P AD=0.64P PS=3.26U
+ PD=3.28U
M$408 VDD CLK \$1064 VDD pfet_03v3 L=0.28U W=1U AS=0.65P AD=0.65P PS=3.3U
+ PD=3.3U
M$409 \$1076 \$19 VDD VDD pfet_03v3 L=0.28U W=1U AS=0.65P AD=0.42P PS=3.3U
+ PD=1.84U
M$410 VDD \$1112 \$1076 VDD pfet_03v3 L=0.28U W=1U AS=0.42P AD=0.735P PS=1.84U
+ PD=2.47U
M$411 \$1077 \$1076 VDD VDD pfet_03v3 L=0.28U W=1U AS=0.735P AD=0.64P PS=2.47U
+ PD=3.28U
M$412 \$1065 \$1077 VDD VDD pfet_03v3 L=0.28U W=1U AS=0.65P AD=0.42P PS=3.3U
+ PD=1.84U
M$413 VDD \$1078 \$1065 VDD pfet_03v3 L=0.28U W=1U AS=0.42P AD=0.735P PS=1.84U
+ PD=2.47U
M$414 \$1066 \$1065 VDD VDD pfet_03v3 L=0.28U W=1U AS=0.735P AD=0.635P PS=2.47U
+ PD=3.27U
M$415 \$1067 \$1066 VDD VDD pfet_03v3 L=0.28U W=1U AS=0.55P AD=0.65P PS=3.1U
+ PD=3.3U
M$416 REC3 \$1067 E3 VDD pfet_03v3 L=0.28U W=1U AS=0.65P AD=0.65P PS=3.3U
+ PD=3.3U
M$417 \$1108 \$1064 \$1071 VDD pfet_03v3 L=0.28U W=1U AS=0.65P AD=0.65P PS=3.3U
+ PD=3.3U
M$418 \$1110 RSTN VDD VDD pfet_03v3 L=0.28U W=1U AS=0.65P AD=0.65P PS=3.3U
+ PD=3.3U
M$419 \$1110 \$1108 VDD VDD pfet_03v3 L=0.28U W=1U AS=0.65P AD=0.65P PS=3.3U
+ PD=3.3U
M$420 \$1135 \$1110 \$1108 VDD pfet_03v3 L=0.28U W=1U AS=0.65P AD=0.65P PS=3.3U
+ PD=3.3U
M$421 VDD \$1073 \$1135 VDD pfet_03v3 L=0.28U W=1U AS=0.65P AD=0.65P PS=3.3U
+ PD=3.3U
M$422 \$1112 \$1110 VDD VDD pfet_03v3 L=0.28U W=1U AS=0.65P AD=0.65P PS=3.3U
+ PD=3.3U
M$423 \$1113 \$1110 VDD VDD pfet_03v3 L=0.28U W=1U AS=0.65P AD=0.65P PS=3.3U
+ PD=3.3U
M$424 \$1114 \$1113 VDD VDD pfet_03v3 L=0.28U W=1U AS=0.65P AD=0.65P PS=3.3U
+ PD=3.3U
M$425 \$1115 \$60 VDD VDD pfet_03v3 L=0.28U W=1U AS=0.65P AD=0.42P PS=3.3U
+ PD=1.84U
M$426 VDD \$1112 \$1115 VDD pfet_03v3 L=0.28U W=1U AS=0.42P AD=0.735P PS=1.84U
+ PD=2.47U
M$427 \$1118 \$1115 VDD VDD pfet_03v3 L=0.28U W=1U AS=0.735P AD=0.63P PS=2.47U
+ PD=3.26U
M$428 \$1116 \$1118 VDD VDD pfet_03v3 L=0.28U W=1U AS=0.65P AD=0.42P PS=3.3U
+ PD=1.84U
M$429 VDD \$1067 \$1116 VDD pfet_03v3 L=0.28U W=1U AS=0.42P AD=0.735P PS=1.84U
+ PD=2.47U
M$430 \$1119 \$1116 VDD VDD pfet_03v3 L=0.28U W=1U AS=0.735P AD=0.63P PS=2.47U
+ PD=3.26U
M$431 \$1078 \$1119 VDD VDD pfet_03v3 L=0.28U W=1U AS=0.56P AD=0.65P PS=3.12U
+ PD=3.3U
M$432 IPG3 \$1078 E3 VDD pfet_03v3 L=0.28U W=1U AS=0.65P AD=0.65P PS=3.3U
+ PD=3.3U
M$433 \$1150 \$1149 VDD VDD pfet_03v3 L=0.28U W=1U AS=0.76P AD=0.65P PS=3.52U
+ PD=3.3U
M$434 VDD \$1150 \$1151 VDD pfet_03v3 L=0.28U W=1U AS=0.65P AD=0.65P PS=3.3U
+ PD=3.3U
M$435 \$1151 RSTN VDD VDD pfet_03v3 L=0.28U W=1U AS=0.65P AD=0.65P PS=3.3U
+ PD=3.3U
M$436 \$1149 \$1148 \$1151 VDD pfet_03v3 L=0.28U W=1U AS=0.65P AD=0.59P PS=3.3U
+ PD=3.18U
M$437 \$1153 EN2 \$1149 VDD pfet_03v3 L=0.28U W=1U AS=0.63P AD=0.605P PS=3.26U
+ PD=3.21U
M$438 VDD \$1154 \$1153 VDD pfet_03v3 L=0.28U W=1U AS=0.63P AD=0.54P PS=3.26U
+ PD=3.08U
M$439 VDD \$1148 \$1154 VDD pfet_03v3 L=0.28U W=1U AS=0.63P AD=0.64P PS=3.26U
+ PD=3.28U
M$440 VDD CLK \$1148 VDD pfet_03v3 L=0.28U W=1U AS=0.65P AD=0.65P PS=3.3U
+ PD=3.3U
M$441 \$1155 \$19 VDD VDD pfet_03v3 L=0.28U W=1U AS=0.65P AD=0.42P PS=3.3U
+ PD=1.84U
M$442 VDD \$1196 \$1155 VDD pfet_03v3 L=0.28U W=1U AS=0.42P AD=0.735P PS=1.84U
+ PD=2.47U
M$443 \$1156 \$1155 VDD VDD pfet_03v3 L=0.28U W=1U AS=0.735P AD=0.64P PS=2.47U
+ PD=3.28U
M$444 \$1157 \$1156 VDD VDD pfet_03v3 L=0.28U W=1U AS=0.65P AD=0.42P PS=3.3U
+ PD=1.84U
M$445 VDD \$1158 \$1157 VDD pfet_03v3 L=0.28U W=1U AS=0.42P AD=0.735P PS=1.84U
+ PD=2.47U
M$446 \$1159 \$1157 VDD VDD pfet_03v3 L=0.28U W=1U AS=0.735P AD=0.635P PS=2.47U
+ PD=3.27U
M$447 \$1160 \$1159 VDD VDD pfet_03v3 L=0.28U W=1U AS=0.55P AD=0.65P PS=3.1U
+ PD=3.3U
M$448 REC2 \$1160 E2 VDD pfet_03v3 L=0.28U W=1U AS=0.65P AD=0.65P PS=3.3U
+ PD=3.3U
M$449 \$1192 \$1148 \$1150 VDD pfet_03v3 L=0.28U W=1U AS=0.65P AD=0.65P PS=3.3U
+ PD=3.3U
M$450 \$1194 RSTN VDD VDD pfet_03v3 L=0.28U W=1U AS=0.65P AD=0.65P PS=3.3U
+ PD=3.3U
M$451 \$1194 \$1192 VDD VDD pfet_03v3 L=0.28U W=1U AS=0.65P AD=0.65P PS=3.3U
+ PD=3.3U
M$452 \$1219 \$1194 \$1192 VDD pfet_03v3 L=0.28U W=1U AS=0.65P AD=0.65P PS=3.3U
+ PD=3.3U
M$453 VDD \$1154 \$1219 VDD pfet_03v3 L=0.28U W=1U AS=0.65P AD=0.65P PS=3.3U
+ PD=3.3U
M$454 \$1196 \$1194 VDD VDD pfet_03v3 L=0.28U W=1U AS=0.65P AD=0.65P PS=3.3U
+ PD=3.3U
M$455 \$1197 \$1194 VDD VDD pfet_03v3 L=0.28U W=1U AS=0.65P AD=0.65P PS=3.3U
+ PD=3.3U
M$456 \$1198 \$1197 VDD VDD pfet_03v3 L=0.28U W=1U AS=0.65P AD=0.65P PS=3.3U
+ PD=3.3U
M$457 \$1199 \$60 VDD VDD pfet_03v3 L=0.28U W=1U AS=0.65P AD=0.42P PS=3.3U
+ PD=1.84U
M$458 VDD \$1196 \$1199 VDD pfet_03v3 L=0.28U W=1U AS=0.42P AD=0.735P PS=1.84U
+ PD=2.47U
M$459 \$1200 \$1199 VDD VDD pfet_03v3 L=0.28U W=1U AS=0.735P AD=0.63P PS=2.47U
+ PD=3.26U
M$460 \$1201 \$1200 VDD VDD pfet_03v3 L=0.28U W=1U AS=0.65P AD=0.42P PS=3.3U
+ PD=1.84U
M$461 VDD \$1160 \$1201 VDD pfet_03v3 L=0.28U W=1U AS=0.42P AD=0.735P PS=1.84U
+ PD=2.47U
M$462 \$1202 \$1201 VDD VDD pfet_03v3 L=0.28U W=1U AS=0.735P AD=0.63P PS=2.47U
+ PD=3.26U
M$463 \$1158 \$1202 VDD VDD pfet_03v3 L=0.28U W=1U AS=0.56P AD=0.65P PS=3.12U
+ PD=3.3U
M$464 IPG2 \$1158 E2 VDD pfet_03v3 L=0.28U W=1U AS=0.65P AD=0.65P PS=3.3U
+ PD=3.3U
M$465 \$1234 \$1233 VDD VDD pfet_03v3 L=0.28U W=1U AS=0.76P AD=0.65P PS=3.52U
+ PD=3.3U
M$466 VDD \$1234 \$1235 VDD pfet_03v3 L=0.28U W=1U AS=0.65P AD=0.65P PS=3.3U
+ PD=3.3U
M$467 \$1235 RSTN VDD VDD pfet_03v3 L=0.28U W=1U AS=0.65P AD=0.65P PS=3.3U
+ PD=3.3U
M$468 \$1233 \$1232 \$1235 VDD pfet_03v3 L=0.28U W=1U AS=0.65P AD=0.59P PS=3.3U
+ PD=3.18U
M$469 \$1237 EN1 \$1233 VDD pfet_03v3 L=0.28U W=1U AS=0.63P AD=0.605P PS=3.26U
+ PD=3.21U
M$470 VDD \$1238 \$1237 VDD pfet_03v3 L=0.28U W=1U AS=0.63P AD=0.54P PS=3.26U
+ PD=3.08U
M$471 VDD \$1232 \$1238 VDD pfet_03v3 L=0.28U W=1U AS=0.63P AD=0.64P PS=3.26U
+ PD=3.28U
M$472 VDD CLK \$1232 VDD pfet_03v3 L=0.28U W=1U AS=0.65P AD=0.65P PS=3.3U
+ PD=3.3U
M$473 \$1239 \$19 VDD VDD pfet_03v3 L=0.28U W=1U AS=0.65P AD=0.42P PS=3.3U
+ PD=1.84U
M$474 VDD \$1259 \$1239 VDD pfet_03v3 L=0.28U W=1U AS=0.42P AD=0.735P PS=1.84U
+ PD=2.47U
M$475 \$1240 \$1239 VDD VDD pfet_03v3 L=0.28U W=1U AS=0.735P AD=0.64P PS=2.47U
+ PD=3.28U
M$476 \$1241 \$1240 VDD VDD pfet_03v3 L=0.28U W=1U AS=0.65P AD=0.42P PS=3.3U
+ PD=1.84U
M$477 VDD \$1242 \$1241 VDD pfet_03v3 L=0.28U W=1U AS=0.42P AD=0.735P PS=1.84U
+ PD=2.47U
M$478 \$1243 \$1241 VDD VDD pfet_03v3 L=0.28U W=1U AS=0.735P AD=0.635P PS=2.47U
+ PD=3.27U
M$479 \$1244 \$1243 VDD VDD pfet_03v3 L=0.28U W=1U AS=0.55P AD=0.65P PS=3.1U
+ PD=3.3U
M$480 REC1 \$1244 E1 VDD pfet_03v3 L=0.28U W=1U AS=0.65P AD=0.65P PS=3.3U
+ PD=3.3U
M$481 \$1277 \$1232 \$1234 VDD pfet_03v3 L=0.28U W=1U AS=0.65P AD=0.65P PS=3.3U
+ PD=3.3U
M$482 \$1279 RSTN VDD VDD pfet_03v3 L=0.28U W=1U AS=0.65P AD=0.65P PS=3.3U
+ PD=3.3U
M$483 \$1279 \$1277 VDD VDD pfet_03v3 L=0.28U W=1U AS=0.65P AD=0.65P PS=3.3U
+ PD=3.3U
M$484 \$1303 \$1279 \$1277 VDD pfet_03v3 L=0.28U W=1U AS=0.65P AD=0.65P PS=3.3U
+ PD=3.3U
M$485 VDD \$1238 \$1303 VDD pfet_03v3 L=0.28U W=1U AS=0.65P AD=0.65P PS=3.3U
+ PD=3.3U
M$486 \$1259 \$1279 VDD VDD pfet_03v3 L=0.28U W=1U AS=0.65P AD=0.65P PS=3.3U
+ PD=3.3U
M$487 \$1281 \$1279 VDD VDD pfet_03v3 L=0.28U W=1U AS=0.65P AD=0.65P PS=3.3U
+ PD=3.3U
M$488 \$1282 \$1281 VDD VDD pfet_03v3 L=0.28U W=1U AS=0.65P AD=0.65P PS=3.3U
+ PD=3.3U
M$489 \$1283 \$60 VDD VDD pfet_03v3 L=0.28U W=1U AS=0.65P AD=0.42P PS=3.3U
+ PD=1.84U
M$490 VDD \$1259 \$1283 VDD pfet_03v3 L=0.28U W=1U AS=0.42P AD=0.735P PS=1.84U
+ PD=2.47U
M$491 \$1286 \$1283 VDD VDD pfet_03v3 L=0.28U W=1U AS=0.735P AD=0.63P PS=2.47U
+ PD=3.26U
M$492 \$1284 \$1286 VDD VDD pfet_03v3 L=0.28U W=1U AS=0.65P AD=0.42P PS=3.3U
+ PD=1.84U
M$493 VDD \$1244 \$1284 VDD pfet_03v3 L=0.28U W=1U AS=0.42P AD=0.735P PS=1.84U
+ PD=2.47U
M$494 \$1287 \$1284 VDD VDD pfet_03v3 L=0.28U W=1U AS=0.735P AD=0.63P PS=2.47U
+ PD=3.26U
M$495 \$1242 \$1287 VDD VDD pfet_03v3 L=0.28U W=1U AS=0.56P AD=0.65P PS=3.12U
+ PD=3.3U
M$496 IPG1 \$1242 E1 VDD pfet_03v3 L=0.28U W=1U AS=0.65P AD=0.65P PS=3.3U
+ PD=3.3U
M$497 \$1318 \$1317 VDD VDD pfet_03v3 L=0.28U W=1U AS=0.76P AD=0.65P PS=3.52U
+ PD=3.3U
M$498 VDD \$1318 \$1319 VDD pfet_03v3 L=0.28U W=1U AS=0.65P AD=0.65P PS=3.3U
+ PD=3.3U
M$499 \$1319 RSTN VDD VDD pfet_03v3 L=0.28U W=1U AS=0.65P AD=0.65P PS=3.3U
+ PD=3.3U
M$500 \$1317 \$1316 \$1319 VDD pfet_03v3 L=0.28U W=1U AS=0.65P AD=0.59P PS=3.3U
+ PD=3.18U
M$501 \$1321 EN0 \$1317 VDD pfet_03v3 L=0.28U W=1U AS=0.63P AD=0.605P PS=3.26U
+ PD=3.21U
M$502 VDD \$1322 \$1321 VDD pfet_03v3 L=0.28U W=1U AS=0.63P AD=0.54P PS=3.26U
+ PD=3.08U
M$503 VDD \$1316 \$1322 VDD pfet_03v3 L=0.28U W=1U AS=0.63P AD=0.64P PS=3.26U
+ PD=3.28U
M$504 VDD CLK \$1316 VDD pfet_03v3 L=0.28U W=1U AS=0.65P AD=0.65P PS=3.3U
+ PD=3.3U
M$505 \$1323 \$19 VDD VDD pfet_03v3 L=0.28U W=1U AS=0.65P AD=0.42P PS=3.3U
+ PD=1.84U
M$506 VDD \$1364 \$1323 VDD pfet_03v3 L=0.28U W=1U AS=0.42P AD=0.735P PS=1.84U
+ PD=2.47U
M$507 \$1324 \$1323 VDD VDD pfet_03v3 L=0.28U W=1U AS=0.735P AD=0.64P PS=2.47U
+ PD=3.28U
M$508 \$1325 \$1324 VDD VDD pfet_03v3 L=0.28U W=1U AS=0.65P AD=0.42P PS=3.3U
+ PD=1.84U
M$509 VDD \$1326 \$1325 VDD pfet_03v3 L=0.28U W=1U AS=0.42P AD=0.735P PS=1.84U
+ PD=2.47U
M$510 \$1327 \$1325 VDD VDD pfet_03v3 L=0.28U W=1U AS=0.735P AD=0.635P PS=2.47U
+ PD=3.27U
M$511 \$1328 \$1327 VDD VDD pfet_03v3 L=0.28U W=1U AS=0.55P AD=0.65P PS=3.1U
+ PD=3.3U
M$512 REC0 \$1328 E0 VDD pfet_03v3 L=0.28U W=1U AS=0.65P AD=0.65P PS=3.3U
+ PD=3.3U
M$513 \$1360 \$1316 \$1318 VDD pfet_03v3 L=0.28U W=1U AS=0.65P AD=0.65P PS=3.3U
+ PD=3.3U
M$514 \$1362 RSTN VDD VDD pfet_03v3 L=0.28U W=1U AS=0.65P AD=0.65P PS=3.3U
+ PD=3.3U
M$515 \$1362 \$1360 VDD VDD pfet_03v3 L=0.28U W=1U AS=0.65P AD=0.65P PS=3.3U
+ PD=3.3U
M$516 \$1387 \$1362 \$1360 VDD pfet_03v3 L=0.28U W=1U AS=0.65P AD=0.65P PS=3.3U
+ PD=3.3U
M$517 VDD \$1322 \$1387 VDD pfet_03v3 L=0.28U W=1U AS=0.65P AD=0.65P PS=3.3U
+ PD=3.3U
M$518 \$1364 \$1362 VDD VDD pfet_03v3 L=0.28U W=1U AS=0.65P AD=0.65P PS=3.3U
+ PD=3.3U
M$519 \$1365 \$1362 VDD VDD pfet_03v3 L=0.28U W=1U AS=0.65P AD=0.65P PS=3.3U
+ PD=3.3U
M$520 \$1366 \$1365 VDD VDD pfet_03v3 L=0.28U W=1U AS=0.65P AD=0.65P PS=3.3U
+ PD=3.3U
M$521 \$1367 \$60 VDD VDD pfet_03v3 L=0.28U W=1U AS=0.65P AD=0.42P PS=3.3U
+ PD=1.84U
M$522 VDD \$1364 \$1367 VDD pfet_03v3 L=0.28U W=1U AS=0.42P AD=0.735P PS=1.84U
+ PD=2.47U
M$523 \$1368 \$1367 VDD VDD pfet_03v3 L=0.28U W=1U AS=0.735P AD=0.63P PS=2.47U
+ PD=3.26U
M$524 \$1369 \$1368 VDD VDD pfet_03v3 L=0.28U W=1U AS=0.65P AD=0.42P PS=3.3U
+ PD=1.84U
M$525 VDD \$1328 \$1369 VDD pfet_03v3 L=0.28U W=1U AS=0.42P AD=0.735P PS=1.84U
+ PD=2.47U
M$526 \$1370 \$1369 VDD VDD pfet_03v3 L=0.28U W=1U AS=0.735P AD=0.63P PS=2.47U
+ PD=3.26U
M$527 \$1326 \$1370 VDD VDD pfet_03v3 L=0.28U W=1U AS=0.56P AD=0.65P PS=3.12U
+ PD=3.3U
M$528 IPG0 \$1326 E0 VDD pfet_03v3 L=0.28U W=1U AS=0.65P AD=0.65P PS=3.3U
+ PD=3.3U
M$529 \$47 \$7 GND GND nfet_03v3 L=0.28U W=1U AS=0.63P AD=0.42P PS=3.26U
+ PD=1.84U
M$530 \$8 \$20 \$47 GND nfet_03v3 L=0.28U W=1U AS=0.42P AD=0.65P PS=1.84U
+ PD=3.3U
M$531 \$9 \$8 GND GND nfet_03v3 L=0.28U W=0.5U AS=0.2425P AD=0.315P PS=1.97U
+ PD=2.26U
M$532 \$10 \$9 GND GND nfet_03v3 L=0.28U W=0.5U AS=0.2825P AD=0.315P PS=2.13U
+ PD=2.26U
M$533 REC15 \$9 E15 GND nfet_03v3 L=0.28U W=1U AS=0.63P AD=0.63P PS=3.26U
+ PD=3.26U
M$534 \$3 \$13 GND GND nfet_03v3 L=0.28U W=1U AS=0.76P AD=0.61P PS=3.52U
+ PD=3.22U
M$535 \$34 \$3 GND GND nfet_03v3 L=0.28U W=1U AS=0.61P AD=0.61P PS=3.22U
+ PD=3.22U
M$536 \$4 RSTN \$34 GND nfet_03v3 L=0.28U W=1U AS=0.61P AD=0.61P PS=3.22U
+ PD=3.22U
M$537 \$13 \$15 \$4 GND nfet_03v3 L=0.28U W=1U AS=0.61P AD=0.61P PS=3.22U
+ PD=3.22U
M$538 \$35 EN15 \$13 GND nfet_03v3 L=0.28U W=1U AS=0.61P AD=0.61P PS=3.22U
+ PD=3.22U
M$539 GND \$2 \$35 GND nfet_03v3 L=0.28U W=1U AS=0.61P AD=0.575P PS=3.22U
+ PD=3.15U
M$540 GND \$2 \$15 GND nfet_03v3 L=0.28U W=1U AS=0.61P AD=0.61P PS=3.22U
+ PD=3.22U
M$541 GND CLK \$2 GND nfet_03v3 L=0.28U W=1U AS=0.63P AD=0.67P PS=3.26U PD=3.34U
M$542 \$50 \$19 GND GND nfet_03v3 L=0.28U W=1U AS=0.63P AD=0.42P PS=3.26U
+ PD=1.84U
M$543 \$6 \$18 \$50 GND nfet_03v3 L=0.28U W=1U AS=0.42P AD=0.65P PS=1.84U
+ PD=3.3U
M$544 \$7 \$6 GND GND nfet_03v3 L=0.28U W=0.5U AS=0.2425P AD=0.3125P PS=1.97U
+ PD=2.25U
M$545 \$51 \$15 \$3 GND nfet_03v3 L=0.28U W=1U AS=0.715P AD=0.61P PS=3.43U
+ PD=3.22U
M$546 \$52 RSTN GND GND nfet_03v3 L=0.28U W=1U AS=0.61P AD=0.61P PS=3.22U
+ PD=3.22U
M$547 \$53 \$51 \$52 GND nfet_03v3 L=0.28U W=1U AS=0.61P AD=0.61P PS=3.22U
+ PD=3.22U
M$548 \$54 \$53 \$51 GND nfet_03v3 L=0.28U W=1U AS=0.61P AD=0.61P PS=3.22U
+ PD=3.22U
M$549 GND \$2 \$54 GND nfet_03v3 L=0.28U W=1U AS=0.61P AD=0.61P PS=3.22U
+ PD=3.22U
M$550 \$18 \$53 GND GND nfet_03v3 L=0.28U W=1U AS=0.61P AD=0.61P PS=3.22U
+ PD=3.22U
M$551 \$55 \$53 GND GND nfet_03v3 L=0.28U W=1U AS=0.61P AD=0.61P PS=3.22U
+ PD=3.22U
M$552 \$56 \$55 GND GND nfet_03v3 L=0.28U W=1U AS=0.61P AD=0.61P PS=3.22U
+ PD=3.22U
M$553 \$75 \$60 GND GND nfet_03v3 L=0.28U W=1U AS=0.63P AD=0.42P PS=3.26U
+ PD=1.84U
M$554 \$57 \$18 \$75 GND nfet_03v3 L=0.28U W=1U AS=0.42P AD=0.65P PS=1.84U
+ PD=3.3U
M$555 \$61 \$57 GND GND nfet_03v3 L=0.28U W=0.5U AS=0.2425P AD=0.31P PS=1.97U
+ PD=2.24U
M$556 \$74 \$61 GND GND nfet_03v3 L=0.28U W=1U AS=0.63P AD=0.42P PS=3.26U
+ PD=1.84U
M$557 \$58 \$10 \$74 GND nfet_03v3 L=0.28U W=1U AS=0.42P AD=0.65P PS=1.84U
+ PD=3.3U
M$558 \$62 \$58 GND GND nfet_03v3 L=0.28U W=0.5U AS=0.2425P AD=0.31P PS=1.97U
+ PD=2.24U
M$559 \$20 \$62 GND GND nfet_03v3 L=0.28U W=0.5U AS=0.285P AD=0.315P PS=2.14U
+ PD=2.26U
M$560 IPG15 \$62 E15 GND nfet_03v3 L=0.28U W=1U AS=0.63P AD=0.63P PS=3.26U
+ PD=3.26U
M$561 \$93 \$92 GND GND nfet_03v3 L=0.28U W=1U AS=0.76P AD=0.61P PS=3.52U
+ PD=3.22U
M$562 \$119 \$93 GND GND nfet_03v3 L=0.28U W=1U AS=0.61P AD=0.61P PS=3.22U
+ PD=3.22U
M$563 \$94 RSTN \$119 GND nfet_03v3 L=0.28U W=1U AS=0.61P AD=0.61P PS=3.22U
+ PD=3.22U
M$564 \$92 \$97 \$94 GND nfet_03v3 L=0.28U W=1U AS=0.61P AD=0.61P PS=3.22U
+ PD=3.22U
M$565 \$120 EN14 \$92 GND nfet_03v3 L=0.28U W=1U AS=0.61P AD=0.61P PS=3.22U
+ PD=3.22U
M$566 GND \$91 \$120 GND nfet_03v3 L=0.28U W=1U AS=0.61P AD=0.575P PS=3.22U
+ PD=3.15U
M$567 GND \$91 \$97 GND nfet_03v3 L=0.28U W=1U AS=0.61P AD=0.61P PS=3.22U
+ PD=3.22U
M$568 GND CLK \$91 GND nfet_03v3 L=0.28U W=1U AS=0.63P AD=0.67P PS=3.26U
+ PD=3.34U
M$569 \$134 \$19 GND GND nfet_03v3 L=0.28U W=1U AS=0.63P AD=0.42P PS=3.26U
+ PD=1.84U
M$570 \$98 \$99 \$134 GND nfet_03v3 L=0.28U W=1U AS=0.42P AD=0.65P PS=1.84U
+ PD=3.3U
M$571 \$100 \$98 GND GND nfet_03v3 L=0.28U W=0.5U AS=0.2425P AD=0.3125P
+ PS=1.97U PD=2.25U
M$572 \$130 \$100 GND GND nfet_03v3 L=0.28U W=1U AS=0.63P AD=0.42P PS=3.26U
+ PD=1.84U
M$573 \$101 \$102 \$130 GND nfet_03v3 L=0.28U W=1U AS=0.42P AD=0.65P PS=1.84U
+ PD=3.3U
M$574 \$103 \$101 GND GND nfet_03v3 L=0.28U W=0.5U AS=0.2425P AD=0.315P
+ PS=1.97U PD=2.26U
M$575 \$104 \$103 GND GND nfet_03v3 L=0.28U W=0.5U AS=0.2825P AD=0.315P
+ PS=2.13U PD=2.26U
M$576 REC14 \$103 E14 GND nfet_03v3 L=0.28U W=1U AS=0.63P AD=0.63P PS=3.26U
+ PD=3.26U
M$577 \$136 \$97 \$93 GND nfet_03v3 L=0.28U W=1U AS=0.715P AD=0.61P PS=3.43U
+ PD=3.22U
M$578 \$137 RSTN GND GND nfet_03v3 L=0.28U W=1U AS=0.61P AD=0.61P PS=3.22U
+ PD=3.22U
M$579 \$138 \$136 \$137 GND nfet_03v3 L=0.28U W=1U AS=0.61P AD=0.61P PS=3.22U
+ PD=3.22U
M$580 \$139 \$138 \$136 GND nfet_03v3 L=0.28U W=1U AS=0.61P AD=0.61P PS=3.22U
+ PD=3.22U
M$581 GND \$91 \$139 GND nfet_03v3 L=0.28U W=1U AS=0.61P AD=0.61P PS=3.22U
+ PD=3.22U
M$582 \$99 \$138 GND GND nfet_03v3 L=0.28U W=1U AS=0.61P AD=0.61P PS=3.22U
+ PD=3.22U
M$583 \$140 \$138 GND GND nfet_03v3 L=0.28U W=1U AS=0.61P AD=0.61P PS=3.22U
+ PD=3.22U
M$584 \$141 \$140 GND GND nfet_03v3 L=0.28U W=1U AS=0.61P AD=0.61P PS=3.22U
+ PD=3.22U
M$585 \$160 \$60 GND GND nfet_03v3 L=0.28U W=1U AS=0.63P AD=0.42P PS=3.26U
+ PD=1.84U
M$586 \$142 \$99 \$160 GND nfet_03v3 L=0.28U W=1U AS=0.42P AD=0.65P PS=1.84U
+ PD=3.3U
M$587 \$143 \$142 GND GND nfet_03v3 L=0.28U W=0.5U AS=0.2425P AD=0.31P PS=1.97U
+ PD=2.24U
M$588 \$157 \$143 GND GND nfet_03v3 L=0.28U W=1U AS=0.63P AD=0.42P PS=3.26U
+ PD=1.84U
M$589 \$144 \$104 \$157 GND nfet_03v3 L=0.28U W=1U AS=0.42P AD=0.65P PS=1.84U
+ PD=3.3U
M$590 \$145 \$144 GND GND nfet_03v3 L=0.28U W=0.5U AS=0.2425P AD=0.31P PS=1.97U
+ PD=2.24U
M$591 \$102 \$145 GND GND nfet_03v3 L=0.28U W=0.5U AS=0.285P AD=0.315P PS=2.14U
+ PD=2.26U
M$592 IPG14 \$145 E14 GND nfet_03v3 L=0.28U W=1U AS=0.63P AD=0.63P PS=3.26U
+ PD=3.26U
M$593 \$177 \$176 GND GND nfet_03v3 L=0.28U W=1U AS=0.76P AD=0.61P PS=3.52U
+ PD=3.22U
M$594 \$202 \$177 GND GND nfet_03v3 L=0.28U W=1U AS=0.61P AD=0.61P PS=3.22U
+ PD=3.22U
M$595 \$178 RSTN \$202 GND nfet_03v3 L=0.28U W=1U AS=0.61P AD=0.61P PS=3.22U
+ PD=3.22U
M$596 \$176 \$181 \$178 GND nfet_03v3 L=0.28U W=1U AS=0.61P AD=0.61P PS=3.22U
+ PD=3.22U
M$597 \$203 EN13 \$176 GND nfet_03v3 L=0.28U W=1U AS=0.61P AD=0.61P PS=3.22U
+ PD=3.22U
M$598 GND \$175 \$203 GND nfet_03v3 L=0.28U W=1U AS=0.61P AD=0.575P PS=3.22U
+ PD=3.15U
M$599 GND \$175 \$181 GND nfet_03v3 L=0.28U W=1U AS=0.61P AD=0.61P PS=3.22U
+ PD=3.22U
M$600 GND CLK \$175 GND nfet_03v3 L=0.28U W=1U AS=0.63P AD=0.67P PS=3.26U
+ PD=3.34U
M$601 \$217 \$19 GND GND nfet_03v3 L=0.28U W=1U AS=0.63P AD=0.42P PS=3.26U
+ PD=1.84U
M$602 \$182 \$223 \$217 GND nfet_03v3 L=0.28U W=1U AS=0.42P AD=0.65P PS=1.84U
+ PD=3.3U
M$603 \$183 \$182 GND GND nfet_03v3 L=0.28U W=0.5U AS=0.2425P AD=0.3125P
+ PS=1.97U PD=2.25U
M$604 \$214 \$183 GND GND nfet_03v3 L=0.28U W=1U AS=0.63P AD=0.42P PS=3.26U
+ PD=1.84U
M$605 \$184 \$185 \$214 GND nfet_03v3 L=0.28U W=1U AS=0.42P AD=0.65P PS=1.84U
+ PD=3.3U
M$606 \$186 \$184 GND GND nfet_03v3 L=0.28U W=0.5U AS=0.2425P AD=0.315P
+ PS=1.97U PD=2.26U
M$607 \$187 \$186 GND GND nfet_03v3 L=0.28U W=0.5U AS=0.2825P AD=0.315P
+ PS=2.13U PD=2.26U
M$608 REC13 \$186 E13 GND nfet_03v3 L=0.28U W=1U AS=0.63P AD=0.63P PS=3.26U
+ PD=3.26U
M$609 \$219 \$181 \$177 GND nfet_03v3 L=0.28U W=1U AS=0.715P AD=0.61P PS=3.43U
+ PD=3.22U
M$610 \$220 RSTN GND GND nfet_03v3 L=0.28U W=1U AS=0.61P AD=0.61P PS=3.22U
+ PD=3.22U
M$611 \$221 \$219 \$220 GND nfet_03v3 L=0.28U W=1U AS=0.61P AD=0.61P PS=3.22U
+ PD=3.22U
M$612 \$222 \$221 \$219 GND nfet_03v3 L=0.28U W=1U AS=0.61P AD=0.61P PS=3.22U
+ PD=3.22U
M$613 GND \$175 \$222 GND nfet_03v3 L=0.28U W=1U AS=0.61P AD=0.61P PS=3.22U
+ PD=3.22U
M$614 \$223 \$221 GND GND nfet_03v3 L=0.28U W=1U AS=0.61P AD=0.61P PS=3.22U
+ PD=3.22U
M$615 \$224 \$221 GND GND nfet_03v3 L=0.28U W=1U AS=0.61P AD=0.61P PS=3.22U
+ PD=3.22U
M$616 \$225 \$224 GND GND nfet_03v3 L=0.28U W=1U AS=0.61P AD=0.61P PS=3.22U
+ PD=3.22U
M$617 \$242 \$60 GND GND nfet_03v3 L=0.28U W=1U AS=0.63P AD=0.42P PS=3.26U
+ PD=1.84U
M$618 \$226 \$223 \$242 GND nfet_03v3 L=0.28U W=1U AS=0.42P AD=0.65P PS=1.84U
+ PD=3.3U
M$619 \$229 \$226 GND GND nfet_03v3 L=0.28U W=0.5U AS=0.2425P AD=0.31P PS=1.97U
+ PD=2.24U
M$620 \$243 \$229 GND GND nfet_03v3 L=0.28U W=1U AS=0.63P AD=0.42P PS=3.26U
+ PD=1.84U
M$621 \$227 \$187 \$243 GND nfet_03v3 L=0.28U W=1U AS=0.42P AD=0.65P PS=1.84U
+ PD=3.3U
M$622 \$230 \$227 GND GND nfet_03v3 L=0.28U W=0.5U AS=0.2425P AD=0.31P PS=1.97U
+ PD=2.24U
M$623 \$185 \$230 GND GND nfet_03v3 L=0.28U W=0.5U AS=0.285P AD=0.315P PS=2.14U
+ PD=2.26U
M$624 IPG13 \$230 E13 GND nfet_03v3 L=0.28U W=1U AS=0.63P AD=0.63P PS=3.26U
+ PD=3.26U
M$625 \$261 \$260 GND GND nfet_03v3 L=0.28U W=1U AS=0.76P AD=0.61P PS=3.52U
+ PD=3.22U
M$626 \$287 \$261 GND GND nfet_03v3 L=0.28U W=1U AS=0.61P AD=0.61P PS=3.22U
+ PD=3.22U
M$627 \$262 RSTN \$287 GND nfet_03v3 L=0.28U W=1U AS=0.61P AD=0.61P PS=3.22U
+ PD=3.22U
M$628 \$260 \$265 \$262 GND nfet_03v3 L=0.28U W=1U AS=0.61P AD=0.61P PS=3.22U
+ PD=3.22U
M$629 \$288 EN12 \$260 GND nfet_03v3 L=0.28U W=1U AS=0.61P AD=0.61P PS=3.22U
+ PD=3.22U
M$630 GND \$247 \$288 GND nfet_03v3 L=0.28U W=1U AS=0.61P AD=0.575P PS=3.22U
+ PD=3.15U
M$631 GND \$247 \$265 GND nfet_03v3 L=0.28U W=1U AS=0.61P AD=0.61P PS=3.22U
+ PD=3.22U
M$632 GND CLK \$247 GND nfet_03v3 L=0.28U W=1U AS=0.63P AD=0.67P PS=3.26U
+ PD=3.34U
M$633 \$302 \$19 GND GND nfet_03v3 L=0.28U W=1U AS=0.63P AD=0.42P PS=3.26U
+ PD=1.84U
M$634 \$266 \$267 \$302 GND nfet_03v3 L=0.28U W=1U AS=0.42P AD=0.65P PS=1.84U
+ PD=3.3U
M$635 \$268 \$266 GND GND nfet_03v3 L=0.28U W=0.5U AS=0.2425P AD=0.3125P
+ PS=1.97U PD=2.25U
M$636 \$299 \$268 GND GND nfet_03v3 L=0.28U W=1U AS=0.63P AD=0.42P PS=3.26U
+ PD=1.84U
M$637 \$269 \$270 \$299 GND nfet_03v3 L=0.28U W=1U AS=0.42P AD=0.65P PS=1.84U
+ PD=3.3U
M$638 \$271 \$269 GND GND nfet_03v3 L=0.28U W=0.5U AS=0.2425P AD=0.315P
+ PS=1.97U PD=2.26U
M$639 \$272 \$271 GND GND nfet_03v3 L=0.28U W=0.5U AS=0.2825P AD=0.315P
+ PS=2.13U PD=2.26U
M$640 REC12 \$271 E12 GND nfet_03v3 L=0.28U W=1U AS=0.63P AD=0.63P PS=3.26U
+ PD=3.26U
M$641 \$304 \$265 \$261 GND nfet_03v3 L=0.28U W=1U AS=0.715P AD=0.61P PS=3.43U
+ PD=3.22U
M$642 \$305 RSTN GND GND nfet_03v3 L=0.28U W=1U AS=0.61P AD=0.61P PS=3.22U
+ PD=3.22U
M$643 \$306 \$304 \$305 GND nfet_03v3 L=0.28U W=1U AS=0.61P AD=0.61P PS=3.22U
+ PD=3.22U
M$644 \$307 \$306 \$304 GND nfet_03v3 L=0.28U W=1U AS=0.61P AD=0.61P PS=3.22U
+ PD=3.22U
M$645 GND \$247 \$307 GND nfet_03v3 L=0.28U W=1U AS=0.61P AD=0.61P PS=3.22U
+ PD=3.22U
M$646 \$267 \$306 GND GND nfet_03v3 L=0.28U W=1U AS=0.61P AD=0.61P PS=3.22U
+ PD=3.22U
M$647 \$308 \$306 GND GND nfet_03v3 L=0.28U W=1U AS=0.61P AD=0.61P PS=3.22U
+ PD=3.22U
M$648 \$309 \$308 GND GND nfet_03v3 L=0.28U W=1U AS=0.61P AD=0.61P PS=3.22U
+ PD=3.22U
M$649 \$327 \$60 GND GND nfet_03v3 L=0.28U W=1U AS=0.63P AD=0.42P PS=3.26U
+ PD=1.84U
M$650 \$310 \$267 \$327 GND nfet_03v3 L=0.28U W=1U AS=0.42P AD=0.65P PS=1.84U
+ PD=3.3U
M$651 \$313 \$310 GND GND nfet_03v3 L=0.28U W=0.5U AS=0.2425P AD=0.31P PS=1.97U
+ PD=2.24U
M$652 \$326 \$313 GND GND nfet_03v3 L=0.28U W=1U AS=0.63P AD=0.42P PS=3.26U
+ PD=1.84U
M$653 \$311 \$272 \$326 GND nfet_03v3 L=0.28U W=1U AS=0.42P AD=0.65P PS=1.84U
+ PD=3.3U
M$654 \$314 \$311 GND GND nfet_03v3 L=0.28U W=0.5U AS=0.2425P AD=0.31P PS=1.97U
+ PD=2.24U
M$655 \$270 \$314 GND GND nfet_03v3 L=0.28U W=0.5U AS=0.285P AD=0.315P PS=2.14U
+ PD=2.26U
M$656 IPG12 \$314 E12 GND nfet_03v3 L=0.28U W=1U AS=0.63P AD=0.63P PS=3.26U
+ PD=3.26U
M$657 \$345 \$344 GND GND nfet_03v3 L=0.28U W=1U AS=0.76P AD=0.61P PS=3.52U
+ PD=3.22U
M$658 \$370 \$345 GND GND nfet_03v3 L=0.28U W=1U AS=0.61P AD=0.61P PS=3.22U
+ PD=3.22U
M$659 \$346 RSTN \$370 GND nfet_03v3 L=0.28U W=1U AS=0.61P AD=0.61P PS=3.22U
+ PD=3.22U
M$660 \$344 \$349 \$346 GND nfet_03v3 L=0.28U W=1U AS=0.61P AD=0.61P PS=3.22U
+ PD=3.22U
M$661 \$371 EN11 \$344 GND nfet_03v3 L=0.28U W=1U AS=0.61P AD=0.61P PS=3.22U
+ PD=3.22U
M$662 GND \$331 \$371 GND nfet_03v3 L=0.28U W=1U AS=0.61P AD=0.575P PS=3.22U
+ PD=3.15U
M$663 GND \$331 \$349 GND nfet_03v3 L=0.28U W=1U AS=0.61P AD=0.61P PS=3.22U
+ PD=3.22U
M$664 GND CLK \$331 GND nfet_03v3 L=0.28U W=1U AS=0.63P AD=0.67P PS=3.26U
+ PD=3.34U
M$665 \$385 \$19 GND GND nfet_03v3 L=0.28U W=1U AS=0.63P AD=0.42P PS=3.26U
+ PD=1.84U
M$666 \$350 \$391 \$385 GND nfet_03v3 L=0.28U W=1U AS=0.42P AD=0.65P PS=1.84U
+ PD=3.3U
M$667 \$351 \$350 GND GND nfet_03v3 L=0.28U W=0.5U AS=0.2425P AD=0.3125P
+ PS=1.97U PD=2.25U
M$668 \$382 \$351 GND GND nfet_03v3 L=0.28U W=1U AS=0.63P AD=0.42P PS=3.26U
+ PD=1.84U
M$669 \$352 \$353 \$382 GND nfet_03v3 L=0.28U W=1U AS=0.42P AD=0.65P PS=1.84U
+ PD=3.3U
M$670 \$354 \$352 GND GND nfet_03v3 L=0.28U W=0.5U AS=0.2425P AD=0.315P
+ PS=1.97U PD=2.26U
M$671 \$355 \$354 GND GND nfet_03v3 L=0.28U W=0.5U AS=0.2825P AD=0.315P
+ PS=2.13U PD=2.26U
M$672 REC11 \$354 E11 GND nfet_03v3 L=0.28U W=1U AS=0.63P AD=0.63P PS=3.26U
+ PD=3.26U
M$673 \$387 \$349 \$345 GND nfet_03v3 L=0.28U W=1U AS=0.715P AD=0.61P PS=3.43U
+ PD=3.22U
M$674 \$388 RSTN GND GND nfet_03v3 L=0.28U W=1U AS=0.61P AD=0.61P PS=3.22U
+ PD=3.22U
M$675 \$389 \$387 \$388 GND nfet_03v3 L=0.28U W=1U AS=0.61P AD=0.61P PS=3.22U
+ PD=3.22U
M$676 \$390 \$389 \$387 GND nfet_03v3 L=0.28U W=1U AS=0.61P AD=0.61P PS=3.22U
+ PD=3.22U
M$677 GND \$331 \$390 GND nfet_03v3 L=0.28U W=1U AS=0.61P AD=0.61P PS=3.22U
+ PD=3.22U
M$678 \$391 \$389 GND GND nfet_03v3 L=0.28U W=1U AS=0.61P AD=0.61P PS=3.22U
+ PD=3.22U
M$679 \$392 \$389 GND GND nfet_03v3 L=0.28U W=1U AS=0.61P AD=0.61P PS=3.22U
+ PD=3.22U
M$680 \$393 \$392 GND GND nfet_03v3 L=0.28U W=1U AS=0.61P AD=0.61P PS=3.22U
+ PD=3.22U
M$681 \$409 \$60 GND GND nfet_03v3 L=0.28U W=1U AS=0.63P AD=0.42P PS=3.26U
+ PD=1.84U
M$682 \$394 \$391 \$409 GND nfet_03v3 L=0.28U W=1U AS=0.42P AD=0.65P PS=1.84U
+ PD=3.3U
M$683 \$397 \$394 GND GND nfet_03v3 L=0.28U W=0.5U AS=0.2425P AD=0.31P PS=1.97U
+ PD=2.24U
M$684 \$412 \$397 GND GND nfet_03v3 L=0.28U W=1U AS=0.63P AD=0.42P PS=3.26U
+ PD=1.84U
M$685 \$395 \$355 \$412 GND nfet_03v3 L=0.28U W=1U AS=0.42P AD=0.65P PS=1.84U
+ PD=3.3U
M$686 \$398 \$395 GND GND nfet_03v3 L=0.28U W=0.5U AS=0.2425P AD=0.31P PS=1.97U
+ PD=2.24U
M$687 \$353 \$398 GND GND nfet_03v3 L=0.28U W=0.5U AS=0.285P AD=0.315P PS=2.14U
+ PD=2.26U
M$688 IPG11 \$398 E11 GND nfet_03v3 L=0.28U W=1U AS=0.63P AD=0.63P PS=3.26U
+ PD=3.26U
M$689 \$429 \$428 GND GND nfet_03v3 L=0.28U W=1U AS=0.76P AD=0.61P PS=3.52U
+ PD=3.22U
M$690 \$454 \$429 GND GND nfet_03v3 L=0.28U W=1U AS=0.61P AD=0.61P PS=3.22U
+ PD=3.22U
M$691 \$430 RSTN \$454 GND nfet_03v3 L=0.28U W=1U AS=0.61P AD=0.61P PS=3.22U
+ PD=3.22U
M$692 \$428 \$433 \$430 GND nfet_03v3 L=0.28U W=1U AS=0.61P AD=0.61P PS=3.22U
+ PD=3.22U
M$693 \$455 EN10 \$428 GND nfet_03v3 L=0.28U W=1U AS=0.61P AD=0.61P PS=3.22U
+ PD=3.22U
M$694 GND \$415 \$455 GND nfet_03v3 L=0.28U W=1U AS=0.61P AD=0.575P PS=3.22U
+ PD=3.15U
M$695 GND \$415 \$433 GND nfet_03v3 L=0.28U W=1U AS=0.61P AD=0.61P PS=3.22U
+ PD=3.22U
M$696 GND CLK \$415 GND nfet_03v3 L=0.28U W=1U AS=0.63P AD=0.67P PS=3.26U
+ PD=3.34U
M$697 \$469 \$19 GND GND nfet_03v3 L=0.28U W=1U AS=0.63P AD=0.42P PS=3.26U
+ PD=1.84U
M$698 \$434 \$475 \$469 GND nfet_03v3 L=0.28U W=1U AS=0.42P AD=0.65P PS=1.84U
+ PD=3.3U
M$699 \$435 \$434 GND GND nfet_03v3 L=0.28U W=0.5U AS=0.2425P AD=0.3125P
+ PS=1.97U PD=2.25U
M$700 \$466 \$435 GND GND nfet_03v3 L=0.28U W=1U AS=0.63P AD=0.42P PS=3.26U
+ PD=1.84U
M$701 \$436 \$437 \$466 GND nfet_03v3 L=0.28U W=1U AS=0.42P AD=0.65P PS=1.84U
+ PD=3.3U
M$702 \$438 \$436 GND GND nfet_03v3 L=0.28U W=0.5U AS=0.2425P AD=0.315P
+ PS=1.97U PD=2.26U
M$703 \$439 \$438 GND GND nfet_03v3 L=0.28U W=0.5U AS=0.2825P AD=0.315P
+ PS=2.13U PD=2.26U
M$704 REC10 \$438 E10 GND nfet_03v3 L=0.28U W=1U AS=0.63P AD=0.63P PS=3.26U
+ PD=3.26U
M$705 \$471 \$433 \$429 GND nfet_03v3 L=0.28U W=1U AS=0.715P AD=0.61P PS=3.43U
+ PD=3.22U
M$706 \$472 RSTN GND GND nfet_03v3 L=0.28U W=1U AS=0.61P AD=0.61P PS=3.22U
+ PD=3.22U
M$707 \$473 \$471 \$472 GND nfet_03v3 L=0.28U W=1U AS=0.61P AD=0.61P PS=3.22U
+ PD=3.22U
M$708 \$474 \$473 \$471 GND nfet_03v3 L=0.28U W=1U AS=0.61P AD=0.61P PS=3.22U
+ PD=3.22U
M$709 GND \$415 \$474 GND nfet_03v3 L=0.28U W=1U AS=0.61P AD=0.61P PS=3.22U
+ PD=3.22U
M$710 \$475 \$473 GND GND nfet_03v3 L=0.28U W=1U AS=0.61P AD=0.61P PS=3.22U
+ PD=3.22U
M$711 \$476 \$473 GND GND nfet_03v3 L=0.28U W=1U AS=0.61P AD=0.61P PS=3.22U
+ PD=3.22U
M$712 \$477 \$476 GND GND nfet_03v3 L=0.28U W=1U AS=0.61P AD=0.61P PS=3.22U
+ PD=3.22U
M$713 \$493 \$60 GND GND nfet_03v3 L=0.28U W=1U AS=0.63P AD=0.42P PS=3.26U
+ PD=1.84U
M$714 \$478 \$475 \$493 GND nfet_03v3 L=0.28U W=1U AS=0.42P AD=0.65P PS=1.84U
+ PD=3.3U
M$715 \$481 \$478 GND GND nfet_03v3 L=0.28U W=0.5U AS=0.2425P AD=0.31P PS=1.97U
+ PD=2.24U
M$716 \$495 \$481 GND GND nfet_03v3 L=0.28U W=1U AS=0.63P AD=0.42P PS=3.26U
+ PD=1.84U
M$717 \$479 \$439 \$495 GND nfet_03v3 L=0.28U W=1U AS=0.42P AD=0.65P PS=1.84U
+ PD=3.3U
M$718 \$482 \$479 GND GND nfet_03v3 L=0.28U W=0.5U AS=0.2425P AD=0.31P PS=1.97U
+ PD=2.24U
M$719 \$437 \$482 GND GND nfet_03v3 L=0.28U W=0.5U AS=0.285P AD=0.315P PS=2.14U
+ PD=2.26U
M$720 IPG10 \$482 E10 GND nfet_03v3 L=0.28U W=1U AS=0.63P AD=0.63P PS=3.26U
+ PD=3.26U
M$721 \$513 \$512 GND GND nfet_03v3 L=0.28U W=1U AS=0.76P AD=0.61P PS=3.52U
+ PD=3.22U
M$722 \$539 \$513 GND GND nfet_03v3 L=0.28U W=1U AS=0.61P AD=0.61P PS=3.22U
+ PD=3.22U
M$723 \$514 RSTN \$539 GND nfet_03v3 L=0.28U W=1U AS=0.61P AD=0.61P PS=3.22U
+ PD=3.22U
M$724 \$512 \$517 \$514 GND nfet_03v3 L=0.28U W=1U AS=0.61P AD=0.61P PS=3.22U
+ PD=3.22U
M$725 \$540 EN9 \$512 GND nfet_03v3 L=0.28U W=1U AS=0.61P AD=0.61P PS=3.22U
+ PD=3.22U
M$726 GND \$499 \$540 GND nfet_03v3 L=0.28U W=1U AS=0.61P AD=0.575P PS=3.22U
+ PD=3.15U
M$727 GND \$499 \$517 GND nfet_03v3 L=0.28U W=1U AS=0.61P AD=0.61P PS=3.22U
+ PD=3.22U
M$728 GND CLK \$499 GND nfet_03v3 L=0.28U W=1U AS=0.63P AD=0.67P PS=3.26U
+ PD=3.34U
M$729 \$554 \$19 GND GND nfet_03v3 L=0.28U W=1U AS=0.63P AD=0.42P PS=3.26U
+ PD=1.84U
M$730 \$518 \$519 \$554 GND nfet_03v3 L=0.28U W=1U AS=0.42P AD=0.65P PS=1.84U
+ PD=3.3U
M$731 \$520 \$518 GND GND nfet_03v3 L=0.28U W=0.5U AS=0.2425P AD=0.3125P
+ PS=1.97U PD=2.25U
M$732 \$551 \$520 GND GND nfet_03v3 L=0.28U W=1U AS=0.63P AD=0.42P PS=3.26U
+ PD=1.84U
M$733 \$521 \$522 \$551 GND nfet_03v3 L=0.28U W=1U AS=0.42P AD=0.65P PS=1.84U
+ PD=3.3U
M$734 \$523 \$521 GND GND nfet_03v3 L=0.28U W=0.5U AS=0.2425P AD=0.315P
+ PS=1.97U PD=2.26U
M$735 \$524 \$523 GND GND nfet_03v3 L=0.28U W=0.5U AS=0.2825P AD=0.315P
+ PS=2.13U PD=2.26U
M$736 REC9 \$523 E9 GND nfet_03v3 L=0.28U W=1U AS=0.63P AD=0.63P PS=3.26U
+ PD=3.26U
M$737 \$556 \$517 \$513 GND nfet_03v3 L=0.28U W=1U AS=0.715P AD=0.61P PS=3.43U
+ PD=3.22U
M$738 \$557 RSTN GND GND nfet_03v3 L=0.28U W=1U AS=0.61P AD=0.61P PS=3.22U
+ PD=3.22U
M$739 \$558 \$556 \$557 GND nfet_03v3 L=0.28U W=1U AS=0.61P AD=0.61P PS=3.22U
+ PD=3.22U
M$740 \$559 \$558 \$556 GND nfet_03v3 L=0.28U W=1U AS=0.61P AD=0.61P PS=3.22U
+ PD=3.22U
M$741 GND \$499 \$559 GND nfet_03v3 L=0.28U W=1U AS=0.61P AD=0.61P PS=3.22U
+ PD=3.22U
M$742 \$519 \$558 GND GND nfet_03v3 L=0.28U W=1U AS=0.61P AD=0.61P PS=3.22U
+ PD=3.22U
M$743 \$560 \$558 GND GND nfet_03v3 L=0.28U W=1U AS=0.61P AD=0.61P PS=3.22U
+ PD=3.22U
M$744 \$561 \$560 GND GND nfet_03v3 L=0.28U W=1U AS=0.61P AD=0.61P PS=3.22U
+ PD=3.22U
M$745 \$575 \$60 GND GND nfet_03v3 L=0.28U W=1U AS=0.63P AD=0.42P PS=3.26U
+ PD=1.84U
M$746 \$587 \$519 \$575 GND nfet_03v3 L=0.28U W=1U AS=0.42P AD=0.65P PS=1.84U
+ PD=3.3U
M$747 \$567 \$587 GND GND nfet_03v3 L=0.28U W=0.5U AS=0.2425P AD=0.31P PS=1.97U
+ PD=2.24U
M$748 \$572 \$567 GND GND nfet_03v3 L=0.28U W=1U AS=0.63P AD=0.42P PS=3.26U
+ PD=1.84U
M$749 \$562 \$524 \$572 GND nfet_03v3 L=0.28U W=1U AS=0.42P AD=0.65P PS=1.84U
+ PD=3.3U
M$750 \$568 \$562 GND GND nfet_03v3 L=0.28U W=0.5U AS=0.2425P AD=0.31P PS=1.97U
+ PD=2.24U
M$751 \$522 \$568 GND GND nfet_03v3 L=0.28U W=0.5U AS=0.285P AD=0.315P PS=2.14U
+ PD=2.26U
M$752 IPG9 \$568 E9 GND nfet_03v3 L=0.28U W=1U AS=0.63P AD=0.63P PS=3.26U
+ PD=3.26U
M$753 \$621 \$597 \$565 GND nfet_03v3 L=0.28U W=1U AS=0.715P AD=0.61P PS=3.43U
+ PD=3.22U
M$754 \$565 \$584 GND GND nfet_03v3 L=0.28U W=1U AS=0.76P AD=0.61P PS=3.52U
+ PD=3.22U
M$755 \$622 RSTN GND GND nfet_03v3 L=0.28U W=1U AS=0.61P AD=0.61P PS=3.22U
+ PD=3.22U
M$756 \$596 \$565 GND GND nfet_03v3 L=0.28U W=1U AS=0.61P AD=0.61P PS=3.22U
+ PD=3.22U
M$757 \$623 \$621 \$622 GND nfet_03v3 L=0.28U W=1U AS=0.61P AD=0.61P PS=3.22U
+ PD=3.22U
M$758 \$566 RSTN \$596 GND nfet_03v3 L=0.28U W=1U AS=0.61P AD=0.61P PS=3.22U
+ PD=3.22U
M$759 \$624 \$623 \$621 GND nfet_03v3 L=0.28U W=1U AS=0.61P AD=0.61P PS=3.22U
+ PD=3.22U
M$760 \$584 \$597 \$566 GND nfet_03v3 L=0.28U W=1U AS=0.61P AD=0.61P PS=3.22U
+ PD=3.22U
M$761 GND \$564 \$624 GND nfet_03v3 L=0.28U W=1U AS=0.61P AD=0.61P PS=3.22U
+ PD=3.22U
M$762 \$599 MODE \$584 GND nfet_03v3 L=0.28U W=1U AS=0.61P AD=0.61P PS=3.22U
+ PD=3.22U
M$763 \$19 \$623 GND GND nfet_03v3 L=0.28U W=1U AS=0.61P AD=0.61P PS=3.22U
+ PD=3.22U
M$764 GND \$564 \$599 GND nfet_03v3 L=0.28U W=1U AS=0.61P AD=0.575P PS=3.22U
+ PD=3.15U
M$765 \$625 \$623 GND GND nfet_03v3 L=0.28U W=1U AS=0.61P AD=0.61P PS=3.22U
+ PD=3.22U
M$766 GND \$564 \$597 GND nfet_03v3 L=0.28U W=1U AS=0.61P AD=0.61P PS=3.22U
+ PD=3.22U
M$767 \$60 \$625 GND GND nfet_03v3 L=0.28U W=1U AS=0.61P AD=0.61P PS=3.22U
+ PD=3.22U
M$768 GND CLK \$564 GND nfet_03v3 L=0.28U W=1U AS=0.63P AD=0.61P PS=3.26U
+ PD=3.22U
M$769 \$627 \$646 GND GND nfet_03v3 L=0.28U W=1U AS=0.76P AD=0.61P PS=3.52U
+ PD=3.22U
M$770 \$663 \$627 GND GND nfet_03v3 L=0.28U W=1U AS=0.61P AD=0.61P PS=3.22U
+ PD=3.22U
M$771 \$628 RSTN \$663 GND nfet_03v3 L=0.28U W=1U AS=0.61P AD=0.61P PS=3.22U
+ PD=3.22U
M$772 \$646 \$647 \$628 GND nfet_03v3 L=0.28U W=1U AS=0.61P AD=0.61P PS=3.22U
+ PD=3.22U
M$773 \$664 EN8 \$646 GND nfet_03v3 L=0.28U W=1U AS=0.61P AD=0.61P PS=3.22U
+ PD=3.22U
M$774 GND \$626 \$664 GND nfet_03v3 L=0.28U W=1U AS=0.61P AD=0.575P PS=3.22U
+ PD=3.15U
M$775 GND \$626 \$647 GND nfet_03v3 L=0.28U W=1U AS=0.61P AD=0.61P PS=3.22U
+ PD=3.22U
M$776 GND CLK \$626 GND nfet_03v3 L=0.28U W=1U AS=0.63P AD=0.67P PS=3.26U
+ PD=3.34U
M$777 \$696 \$19 GND GND nfet_03v3 L=0.28U W=1U AS=0.63P AD=0.42P PS=3.26U
+ PD=1.84U
M$778 \$631 \$648 \$696 GND nfet_03v3 L=0.28U W=1U AS=0.42P AD=0.65P PS=1.84U
+ PD=3.3U
M$779 \$632 \$631 GND GND nfet_03v3 L=0.28U W=0.5U AS=0.2425P AD=0.3125P
+ PS=1.97U PD=2.25U
M$780 \$689 \$632 GND GND nfet_03v3 L=0.28U W=1U AS=0.63P AD=0.42P PS=3.26U
+ PD=1.84U
M$781 \$633 \$649 \$689 GND nfet_03v3 L=0.28U W=1U AS=0.42P AD=0.65P PS=1.84U
+ PD=3.3U
M$782 \$634 \$633 GND GND nfet_03v3 L=0.28U W=0.5U AS=0.2425P AD=0.315P
+ PS=1.97U PD=2.26U
M$783 \$635 \$634 GND GND nfet_03v3 L=0.28U W=0.5U AS=0.2825P AD=0.315P
+ PS=2.13U PD=2.26U
M$784 REC8 \$634 E8 GND nfet_03v3 L=0.28U W=1U AS=0.63P AD=0.63P PS=3.26U
+ PD=3.26U
M$785 \$675 \$647 \$627 GND nfet_03v3 L=0.28U W=1U AS=0.715P AD=0.61P PS=3.43U
+ PD=3.22U
M$786 \$676 RSTN GND GND nfet_03v3 L=0.28U W=1U AS=0.61P AD=0.61P PS=3.22U
+ PD=3.22U
M$787 \$677 \$675 \$676 GND nfet_03v3 L=0.28U W=1U AS=0.61P AD=0.61P PS=3.22U
+ PD=3.22U
M$788 \$678 \$677 \$675 GND nfet_03v3 L=0.28U W=1U AS=0.61P AD=0.61P PS=3.22U
+ PD=3.22U
M$789 GND \$626 \$678 GND nfet_03v3 L=0.28U W=1U AS=0.61P AD=0.61P PS=3.22U
+ PD=3.22U
M$790 \$648 \$677 GND GND nfet_03v3 L=0.28U W=1U AS=0.61P AD=0.61P PS=3.22U
+ PD=3.22U
M$791 \$679 \$677 GND GND nfet_03v3 L=0.28U W=1U AS=0.61P AD=0.61P PS=3.22U
+ PD=3.22U
M$792 \$680 \$679 GND GND nfet_03v3 L=0.28U W=1U AS=0.61P AD=0.61P PS=3.22U
+ PD=3.22U
M$793 \$711 \$60 GND GND nfet_03v3 L=0.28U W=1U AS=0.63P AD=0.42P PS=3.26U
+ PD=1.84U
M$794 \$681 \$648 \$711 GND nfet_03v3 L=0.28U W=1U AS=0.42P AD=0.65P PS=1.84U
+ PD=3.3U
M$795 \$698 \$681 GND GND nfet_03v3 L=0.28U W=0.5U AS=0.2425P AD=0.31P PS=1.97U
+ PD=2.24U
M$796 \$713 \$698 GND GND nfet_03v3 L=0.28U W=1U AS=0.63P AD=0.42P PS=3.26U
+ PD=1.84U
M$797 \$682 \$635 \$713 GND nfet_03v3 L=0.28U W=1U AS=0.42P AD=0.65P PS=1.84U
+ PD=3.3U
M$798 \$699 \$682 GND GND nfet_03v3 L=0.28U W=0.5U AS=0.2425P AD=0.31P PS=1.97U
+ PD=2.24U
M$799 \$649 \$699 GND GND nfet_03v3 L=0.28U W=0.5U AS=0.285P AD=0.315P PS=2.14U
+ PD=2.26U
M$800 IPG8 \$699 E8 GND nfet_03v3 L=0.28U W=1U AS=0.63P AD=0.63P PS=3.26U
+ PD=3.26U
M$801 \$730 \$729 GND GND nfet_03v3 L=0.28U W=1U AS=0.76P AD=0.61P PS=3.52U
+ PD=3.22U
M$802 \$755 \$730 GND GND nfet_03v3 L=0.28U W=1U AS=0.61P AD=0.61P PS=3.22U
+ PD=3.22U
M$803 \$731 RSTN \$755 GND nfet_03v3 L=0.28U W=1U AS=0.61P AD=0.61P PS=3.22U
+ PD=3.22U
M$804 \$729 \$734 \$731 GND nfet_03v3 L=0.28U W=1U AS=0.61P AD=0.61P PS=3.22U
+ PD=3.22U
M$805 \$756 EN7 \$729 GND nfet_03v3 L=0.28U W=1U AS=0.61P AD=0.61P PS=3.22U
+ PD=3.22U
M$806 GND \$716 \$756 GND nfet_03v3 L=0.28U W=1U AS=0.61P AD=0.575P PS=3.22U
+ PD=3.15U
M$807 GND \$716 \$734 GND nfet_03v3 L=0.28U W=1U AS=0.61P AD=0.61P PS=3.22U
+ PD=3.22U
M$808 GND CLK \$716 GND nfet_03v3 L=0.28U W=1U AS=0.63P AD=0.67P PS=3.26U
+ PD=3.34U
M$809 \$770 \$19 GND GND nfet_03v3 L=0.28U W=1U AS=0.63P AD=0.42P PS=3.26U
+ PD=1.84U
M$810 \$735 \$776 \$770 GND nfet_03v3 L=0.28U W=1U AS=0.42P AD=0.65P PS=1.84U
+ PD=3.3U
M$811 \$736 \$735 GND GND nfet_03v3 L=0.28U W=0.5U AS=0.2425P AD=0.3125P
+ PS=1.97U PD=2.25U
M$812 \$767 \$736 GND GND nfet_03v3 L=0.28U W=1U AS=0.63P AD=0.42P PS=3.26U
+ PD=1.84U
M$813 \$737 \$738 \$767 GND nfet_03v3 L=0.28U W=1U AS=0.42P AD=0.65P PS=1.84U
+ PD=3.3U
M$814 \$739 \$737 GND GND nfet_03v3 L=0.28U W=0.5U AS=0.2425P AD=0.315P
+ PS=1.97U PD=2.26U
M$815 \$740 \$739 GND GND nfet_03v3 L=0.28U W=0.5U AS=0.2825P AD=0.315P
+ PS=2.13U PD=2.26U
M$816 REC7 \$739 E7 GND nfet_03v3 L=0.28U W=1U AS=0.63P AD=0.63P PS=3.26U
+ PD=3.26U
M$817 \$772 \$734 \$730 GND nfet_03v3 L=0.28U W=1U AS=0.715P AD=0.61P PS=3.43U
+ PD=3.22U
M$818 \$773 RSTN GND GND nfet_03v3 L=0.28U W=1U AS=0.61P AD=0.61P PS=3.22U
+ PD=3.22U
M$819 \$774 \$772 \$773 GND nfet_03v3 L=0.28U W=1U AS=0.61P AD=0.61P PS=3.22U
+ PD=3.22U
M$820 \$775 \$774 \$772 GND nfet_03v3 L=0.28U W=1U AS=0.61P AD=0.61P PS=3.22U
+ PD=3.22U
M$821 GND \$716 \$775 GND nfet_03v3 L=0.28U W=1U AS=0.61P AD=0.61P PS=3.22U
+ PD=3.22U
M$822 \$776 \$774 GND GND nfet_03v3 L=0.28U W=1U AS=0.61P AD=0.61P PS=3.22U
+ PD=3.22U
M$823 \$777 \$774 GND GND nfet_03v3 L=0.28U W=1U AS=0.61P AD=0.61P PS=3.22U
+ PD=3.22U
M$824 \$778 \$777 GND GND nfet_03v3 L=0.28U W=1U AS=0.61P AD=0.61P PS=3.22U
+ PD=3.22U
M$825 \$796 \$60 GND GND nfet_03v3 L=0.28U W=1U AS=0.63P AD=0.42P PS=3.26U
+ PD=1.84U
M$826 \$779 \$776 \$796 GND nfet_03v3 L=0.28U W=1U AS=0.42P AD=0.65P PS=1.84U
+ PD=3.3U
M$827 \$782 \$779 GND GND nfet_03v3 L=0.28U W=0.5U AS=0.2425P AD=0.31P PS=1.97U
+ PD=2.24U
M$828 \$795 \$782 GND GND nfet_03v3 L=0.28U W=1U AS=0.63P AD=0.42P PS=3.26U
+ PD=1.84U
M$829 \$780 \$740 \$795 GND nfet_03v3 L=0.28U W=1U AS=0.42P AD=0.65P PS=1.84U
+ PD=3.3U
M$830 \$783 \$780 GND GND nfet_03v3 L=0.28U W=0.5U AS=0.2425P AD=0.31P PS=1.97U
+ PD=2.24U
M$831 \$738 \$783 GND GND nfet_03v3 L=0.28U W=0.5U AS=0.285P AD=0.315P PS=2.14U
+ PD=2.26U
M$832 IPG7 \$783 E7 GND nfet_03v3 L=0.28U W=1U AS=0.63P AD=0.63P PS=3.26U
+ PD=3.26U
M$833 \$814 \$813 GND GND nfet_03v3 L=0.28U W=1U AS=0.76P AD=0.61P PS=3.52U
+ PD=3.22U
M$834 \$840 \$814 GND GND nfet_03v3 L=0.28U W=1U AS=0.61P AD=0.61P PS=3.22U
+ PD=3.22U
M$835 \$815 RSTN \$840 GND nfet_03v3 L=0.28U W=1U AS=0.61P AD=0.61P PS=3.22U
+ PD=3.22U
M$836 \$813 \$818 \$815 GND nfet_03v3 L=0.28U W=1U AS=0.61P AD=0.61P PS=3.22U
+ PD=3.22U
M$837 \$841 EN6 \$813 GND nfet_03v3 L=0.28U W=1U AS=0.61P AD=0.61P PS=3.22U
+ PD=3.22U
M$838 GND \$812 \$841 GND nfet_03v3 L=0.28U W=1U AS=0.61P AD=0.575P PS=3.22U
+ PD=3.15U
M$839 GND \$812 \$818 GND nfet_03v3 L=0.28U W=1U AS=0.61P AD=0.61P PS=3.22U
+ PD=3.22U
M$840 GND CLK \$812 GND nfet_03v3 L=0.28U W=1U AS=0.63P AD=0.67P PS=3.26U
+ PD=3.34U
M$841 \$855 \$19 GND GND nfet_03v3 L=0.28U W=1U AS=0.63P AD=0.42P PS=3.26U
+ PD=1.84U
M$842 \$819 \$820 \$855 GND nfet_03v3 L=0.28U W=1U AS=0.42P AD=0.65P PS=1.84U
+ PD=3.3U
M$843 \$821 \$819 GND GND nfet_03v3 L=0.28U W=0.5U AS=0.2425P AD=0.3125P
+ PS=1.97U PD=2.25U
M$844 \$851 \$821 GND GND nfet_03v3 L=0.28U W=1U AS=0.63P AD=0.42P PS=3.26U
+ PD=1.84U
M$845 \$822 \$823 \$851 GND nfet_03v3 L=0.28U W=1U AS=0.42P AD=0.65P PS=1.84U
+ PD=3.3U
M$846 \$824 \$822 GND GND nfet_03v3 L=0.28U W=0.5U AS=0.2425P AD=0.315P
+ PS=1.97U PD=2.26U
M$847 \$825 \$824 GND GND nfet_03v3 L=0.28U W=0.5U AS=0.2825P AD=0.315P
+ PS=2.13U PD=2.26U
M$848 REC6 \$824 E6 GND nfet_03v3 L=0.28U W=1U AS=0.63P AD=0.63P PS=3.26U
+ PD=3.26U
M$849 \$857 \$818 \$814 GND nfet_03v3 L=0.28U W=1U AS=0.715P AD=0.61P PS=3.43U
+ PD=3.22U
M$850 \$858 RSTN GND GND nfet_03v3 L=0.28U W=1U AS=0.61P AD=0.61P PS=3.22U
+ PD=3.22U
M$851 \$859 \$857 \$858 GND nfet_03v3 L=0.28U W=1U AS=0.61P AD=0.61P PS=3.22U
+ PD=3.22U
M$852 \$860 \$859 \$857 GND nfet_03v3 L=0.28U W=1U AS=0.61P AD=0.61P PS=3.22U
+ PD=3.22U
M$853 GND \$812 \$860 GND nfet_03v3 L=0.28U W=1U AS=0.61P AD=0.61P PS=3.22U
+ PD=3.22U
M$854 \$820 \$859 GND GND nfet_03v3 L=0.28U W=1U AS=0.61P AD=0.61P PS=3.22U
+ PD=3.22U
M$855 \$861 \$859 GND GND nfet_03v3 L=0.28U W=1U AS=0.61P AD=0.61P PS=3.22U
+ PD=3.22U
M$856 \$862 \$861 GND GND nfet_03v3 L=0.28U W=1U AS=0.61P AD=0.61P PS=3.22U
+ PD=3.22U
M$857 \$880 \$60 GND GND nfet_03v3 L=0.28U W=1U AS=0.63P AD=0.42P PS=3.26U
+ PD=1.84U
M$858 \$863 \$820 \$880 GND nfet_03v3 L=0.28U W=1U AS=0.42P AD=0.65P PS=1.84U
+ PD=3.3U
M$859 \$864 \$863 GND GND nfet_03v3 L=0.28U W=0.5U AS=0.2425P AD=0.31P PS=1.97U
+ PD=2.24U
M$860 \$878 \$864 GND GND nfet_03v3 L=0.28U W=1U AS=0.63P AD=0.42P PS=3.26U
+ PD=1.84U
M$861 \$865 \$825 \$878 GND nfet_03v3 L=0.28U W=1U AS=0.42P AD=0.65P PS=1.84U
+ PD=3.3U
M$862 \$866 \$865 GND GND nfet_03v3 L=0.28U W=0.5U AS=0.2425P AD=0.31P PS=1.97U
+ PD=2.24U
M$863 \$823 \$866 GND GND nfet_03v3 L=0.28U W=0.5U AS=0.285P AD=0.315P PS=2.14U
+ PD=2.26U
M$864 IPG6 \$866 E6 GND nfet_03v3 L=0.28U W=1U AS=0.63P AD=0.63P PS=3.26U
+ PD=3.26U
M$865 \$903 \$902 GND GND nfet_03v3 L=0.28U W=1U AS=0.76P AD=0.61P PS=3.52U
+ PD=3.22U
M$866 \$924 \$903 GND GND nfet_03v3 L=0.28U W=1U AS=0.61P AD=0.61P PS=3.22U
+ PD=3.22U
M$867 \$904 RSTN \$924 GND nfet_03v3 L=0.28U W=1U AS=0.61P AD=0.61P PS=3.22U
+ PD=3.22U
M$868 \$902 \$905 \$904 GND nfet_03v3 L=0.28U W=1U AS=0.61P AD=0.61P PS=3.22U
+ PD=3.22U
M$869 \$925 EN5 \$902 GND nfet_03v3 L=0.28U W=1U AS=0.61P AD=0.61P PS=3.22U
+ PD=3.22U
M$870 GND \$896 \$925 GND nfet_03v3 L=0.28U W=1U AS=0.61P AD=0.575P PS=3.22U
+ PD=3.15U
M$871 GND \$896 \$905 GND nfet_03v3 L=0.28U W=1U AS=0.61P AD=0.61P PS=3.22U
+ PD=3.22U
M$872 GND CLK \$896 GND nfet_03v3 L=0.28U W=1U AS=0.63P AD=0.67P PS=3.26U
+ PD=3.34U
M$873 \$939 \$19 GND GND nfet_03v3 L=0.28U W=1U AS=0.63P AD=0.42P PS=3.26U
+ PD=1.84U
M$874 \$909 \$908 \$939 GND nfet_03v3 L=0.28U W=1U AS=0.42P AD=0.65P PS=1.84U
+ PD=3.3U
M$875 \$910 \$909 GND GND nfet_03v3 L=0.28U W=0.5U AS=0.2425P AD=0.3125P
+ PS=1.97U PD=2.25U
M$876 \$936 \$910 GND GND nfet_03v3 L=0.28U W=1U AS=0.63P AD=0.42P PS=3.26U
+ PD=1.84U
M$877 \$897 \$911 \$936 GND nfet_03v3 L=0.28U W=1U AS=0.42P AD=0.65P PS=1.84U
+ PD=3.3U
M$878 \$898 \$897 GND GND nfet_03v3 L=0.28U W=0.5U AS=0.2425P AD=0.315P
+ PS=1.97U PD=2.26U
M$879 \$899 \$898 GND GND nfet_03v3 L=0.28U W=0.5U AS=0.2825P AD=0.315P
+ PS=2.13U PD=2.26U
M$880 REC5 \$898 E5 GND nfet_03v3 L=0.28U W=1U AS=0.63P AD=0.63P PS=3.26U
+ PD=3.26U
M$881 \$941 \$905 \$903 GND nfet_03v3 L=0.28U W=1U AS=0.715P AD=0.61P PS=3.43U
+ PD=3.22U
M$882 \$942 RSTN GND GND nfet_03v3 L=0.28U W=1U AS=0.61P AD=0.61P PS=3.22U
+ PD=3.22U
M$883 \$943 \$941 \$942 GND nfet_03v3 L=0.28U W=1U AS=0.61P AD=0.61P PS=3.22U
+ PD=3.22U
M$884 \$944 \$943 \$941 GND nfet_03v3 L=0.28U W=1U AS=0.61P AD=0.61P PS=3.22U
+ PD=3.22U
M$885 GND \$896 \$944 GND nfet_03v3 L=0.28U W=1U AS=0.61P AD=0.61P PS=3.22U
+ PD=3.22U
M$886 \$908 \$943 GND GND nfet_03v3 L=0.28U W=1U AS=0.61P AD=0.61P PS=3.22U
+ PD=3.22U
M$887 \$945 \$943 GND GND nfet_03v3 L=0.28U W=1U AS=0.61P AD=0.61P PS=3.22U
+ PD=3.22U
M$888 \$946 \$945 GND GND nfet_03v3 L=0.28U W=1U AS=0.61P AD=0.61P PS=3.22U
+ PD=3.22U
M$889 \$964 \$60 GND GND nfet_03v3 L=0.28U W=1U AS=0.63P AD=0.42P PS=3.26U
+ PD=1.84U
M$890 \$947 \$908 \$964 GND nfet_03v3 L=0.28U W=1U AS=0.42P AD=0.65P PS=1.84U
+ PD=3.3U
M$891 \$950 \$947 GND GND nfet_03v3 L=0.28U W=0.5U AS=0.2425P AD=0.31P PS=1.97U
+ PD=2.24U
M$892 \$963 \$950 GND GND nfet_03v3 L=0.28U W=1U AS=0.63P AD=0.42P PS=3.26U
+ PD=1.84U
M$893 \$948 \$899 \$963 GND nfet_03v3 L=0.28U W=1U AS=0.42P AD=0.65P PS=1.84U
+ PD=3.3U
M$894 \$951 \$948 GND GND nfet_03v3 L=0.28U W=0.5U AS=0.2425P AD=0.31P PS=1.97U
+ PD=2.24U
M$895 \$911 \$951 GND GND nfet_03v3 L=0.28U W=0.5U AS=0.285P AD=0.315P PS=2.14U
+ PD=2.26U
M$896 IPG5 \$951 E5 GND nfet_03v3 L=0.28U W=1U AS=0.63P AD=0.63P PS=3.26U
+ PD=3.26U
M$897 \$983 \$982 GND GND nfet_03v3 L=0.28U W=1U AS=0.76P AD=0.61P PS=3.52U
+ PD=3.22U
M$898 \$1007 \$983 GND GND nfet_03v3 L=0.28U W=1U AS=0.61P AD=0.61P PS=3.22U
+ PD=3.22U
M$899 \$984 RSTN \$1007 GND nfet_03v3 L=0.28U W=1U AS=0.61P AD=0.61P PS=3.22U
+ PD=3.22U
M$900 \$982 \$986 \$984 GND nfet_03v3 L=0.28U W=1U AS=0.61P AD=0.61P PS=3.22U
+ PD=3.22U
M$901 \$1008 EN4 \$982 GND nfet_03v3 L=0.28U W=1U AS=0.61P AD=0.61P PS=3.22U
+ PD=3.22U
M$902 GND \$981 \$1008 GND nfet_03v3 L=0.28U W=1U AS=0.61P AD=0.575P PS=3.22U
+ PD=3.15U
M$903 GND \$981 \$986 GND nfet_03v3 L=0.28U W=1U AS=0.61P AD=0.61P PS=3.22U
+ PD=3.22U
M$904 GND CLK \$981 GND nfet_03v3 L=0.28U W=1U AS=0.63P AD=0.67P PS=3.26U
+ PD=3.34U
M$905 \$1022 \$19 GND GND nfet_03v3 L=0.28U W=1U AS=0.63P AD=0.42P PS=3.26U
+ PD=1.84U
M$906 \$987 \$1028 \$1022 GND nfet_03v3 L=0.28U W=1U AS=0.42P AD=0.65P PS=1.84U
+ PD=3.3U
M$907 \$988 \$987 GND GND nfet_03v3 L=0.28U W=0.5U AS=0.2425P AD=0.3125P
+ PS=1.97U PD=2.25U
M$908 \$1018 \$988 GND GND nfet_03v3 L=0.28U W=1U AS=0.63P AD=0.42P PS=3.26U
+ PD=1.84U
M$909 \$989 \$990 \$1018 GND nfet_03v3 L=0.28U W=1U AS=0.42P AD=0.65P PS=1.84U
+ PD=3.3U
M$910 \$991 \$989 GND GND nfet_03v3 L=0.28U W=0.5U AS=0.2425P AD=0.315P
+ PS=1.97U PD=2.26U
M$911 \$992 \$991 GND GND nfet_03v3 L=0.28U W=0.5U AS=0.2825P AD=0.315P
+ PS=2.13U PD=2.26U
M$912 REC4 \$991 E4 GND nfet_03v3 L=0.28U W=1U AS=0.63P AD=0.63P PS=3.26U
+ PD=3.26U
M$913 \$1024 \$986 \$983 GND nfet_03v3 L=0.28U W=1U AS=0.715P AD=0.61P PS=3.43U
+ PD=3.22U
M$914 \$1025 RSTN GND GND nfet_03v3 L=0.28U W=1U AS=0.61P AD=0.61P PS=3.22U
+ PD=3.22U
M$915 \$1026 \$1024 \$1025 GND nfet_03v3 L=0.28U W=1U AS=0.61P AD=0.61P
+ PS=3.22U PD=3.22U
M$916 \$1027 \$1026 \$1024 GND nfet_03v3 L=0.28U W=1U AS=0.61P AD=0.61P
+ PS=3.22U PD=3.22U
M$917 GND \$981 \$1027 GND nfet_03v3 L=0.28U W=1U AS=0.61P AD=0.61P PS=3.22U
+ PD=3.22U
M$918 \$1028 \$1026 GND GND nfet_03v3 L=0.28U W=1U AS=0.61P AD=0.61P PS=3.22U
+ PD=3.22U
M$919 \$1029 \$1026 GND GND nfet_03v3 L=0.28U W=1U AS=0.61P AD=0.61P PS=3.22U
+ PD=3.22U
M$920 \$1030 \$1029 GND GND nfet_03v3 L=0.28U W=1U AS=0.61P AD=0.61P PS=3.22U
+ PD=3.22U
M$921 \$1048 \$60 GND GND nfet_03v3 L=0.28U W=1U AS=0.63P AD=0.42P PS=3.26U
+ PD=1.84U
M$922 \$1031 \$1028 \$1048 GND nfet_03v3 L=0.28U W=1U AS=0.42P AD=0.65P
+ PS=1.84U PD=3.3U
M$923 \$1032 \$1031 GND GND nfet_03v3 L=0.28U W=0.5U AS=0.2425P AD=0.31P
+ PS=1.97U PD=2.24U
M$924 \$1046 \$1032 GND GND nfet_03v3 L=0.28U W=1U AS=0.63P AD=0.42P PS=3.26U
+ PD=1.84U
M$925 \$1033 \$992 \$1046 GND nfet_03v3 L=0.28U W=1U AS=0.42P AD=0.65P PS=1.84U
+ PD=3.3U
M$926 \$1034 \$1033 GND GND nfet_03v3 L=0.28U W=0.5U AS=0.2425P AD=0.31P
+ PS=1.97U PD=2.24U
M$927 \$990 \$1034 GND GND nfet_03v3 L=0.28U W=0.5U AS=0.285P AD=0.315P
+ PS=2.14U PD=2.26U
M$928 IPG4 \$1034 E4 GND nfet_03v3 L=0.28U W=1U AS=0.63P AD=0.63P PS=3.26U
+ PD=3.26U
M$929 \$1071 \$1070 GND GND nfet_03v3 L=0.28U W=1U AS=0.76P AD=0.61P PS=3.52U
+ PD=3.22U
M$930 \$1091 \$1071 GND GND nfet_03v3 L=0.28U W=1U AS=0.61P AD=0.61P PS=3.22U
+ PD=3.22U
M$931 \$1072 RSTN \$1091 GND nfet_03v3 L=0.28U W=1U AS=0.61P AD=0.61P PS=3.22U
+ PD=3.22U
M$932 \$1070 \$1073 \$1072 GND nfet_03v3 L=0.28U W=1U AS=0.61P AD=0.61P
+ PS=3.22U PD=3.22U
M$933 \$1092 EN3 \$1070 GND nfet_03v3 L=0.28U W=1U AS=0.61P AD=0.61P PS=3.22U
+ PD=3.22U
M$934 GND \$1064 \$1092 GND nfet_03v3 L=0.28U W=1U AS=0.61P AD=0.575P PS=3.22U
+ PD=3.15U
M$935 GND \$1064 \$1073 GND nfet_03v3 L=0.28U W=1U AS=0.61P AD=0.61P PS=3.22U
+ PD=3.22U
M$936 GND CLK \$1064 GND nfet_03v3 L=0.28U W=1U AS=0.63P AD=0.67P PS=3.26U
+ PD=3.34U
M$937 \$1106 \$19 GND GND nfet_03v3 L=0.28U W=1U AS=0.63P AD=0.42P PS=3.26U
+ PD=1.84U
M$938 \$1076 \$1112 \$1106 GND nfet_03v3 L=0.28U W=1U AS=0.42P AD=0.65P
+ PS=1.84U PD=3.3U
M$939 \$1077 \$1076 GND GND nfet_03v3 L=0.28U W=0.5U AS=0.2425P AD=0.3125P
+ PS=1.97U PD=2.25U
M$940 \$1103 \$1077 GND GND nfet_03v3 L=0.28U W=1U AS=0.63P AD=0.42P PS=3.26U
+ PD=1.84U
M$941 \$1065 \$1078 \$1103 GND nfet_03v3 L=0.28U W=1U AS=0.42P AD=0.65P
+ PS=1.84U PD=3.3U
M$942 \$1066 \$1065 GND GND nfet_03v3 L=0.28U W=0.5U AS=0.2425P AD=0.315P
+ PS=1.97U PD=2.26U
M$943 \$1067 \$1066 GND GND nfet_03v3 L=0.28U W=0.5U AS=0.2825P AD=0.315P
+ PS=2.13U PD=2.26U
M$944 REC3 \$1066 E3 GND nfet_03v3 L=0.28U W=1U AS=0.63P AD=0.63P PS=3.26U
+ PD=3.26U
M$945 \$1108 \$1073 \$1071 GND nfet_03v3 L=0.28U W=1U AS=0.715P AD=0.61P
+ PS=3.43U PD=3.22U
M$946 \$1109 RSTN GND GND nfet_03v3 L=0.28U W=1U AS=0.61P AD=0.61P PS=3.22U
+ PD=3.22U
M$947 \$1110 \$1108 \$1109 GND nfet_03v3 L=0.28U W=1U AS=0.61P AD=0.61P
+ PS=3.22U PD=3.22U
M$948 \$1111 \$1110 \$1108 GND nfet_03v3 L=0.28U W=1U AS=0.61P AD=0.61P
+ PS=3.22U PD=3.22U
M$949 GND \$1064 \$1111 GND nfet_03v3 L=0.28U W=1U AS=0.61P AD=0.61P PS=3.22U
+ PD=3.22U
M$950 \$1112 \$1110 GND GND nfet_03v3 L=0.28U W=1U AS=0.61P AD=0.61P PS=3.22U
+ PD=3.22U
M$951 \$1113 \$1110 GND GND nfet_03v3 L=0.28U W=1U AS=0.61P AD=0.61P PS=3.22U
+ PD=3.22U
M$952 \$1114 \$1113 GND GND nfet_03v3 L=0.28U W=1U AS=0.61P AD=0.61P PS=3.22U
+ PD=3.22U
M$953 \$1133 \$60 GND GND nfet_03v3 L=0.28U W=1U AS=0.63P AD=0.42P PS=3.26U
+ PD=1.84U
M$954 \$1115 \$1112 \$1133 GND nfet_03v3 L=0.28U W=1U AS=0.42P AD=0.65P
+ PS=1.84U PD=3.3U
M$955 \$1118 \$1115 GND GND nfet_03v3 L=0.28U W=0.5U AS=0.2425P AD=0.31P
+ PS=1.97U PD=2.24U
M$956 \$1131 \$1118 GND GND nfet_03v3 L=0.28U W=1U AS=0.63P AD=0.42P PS=3.26U
+ PD=1.84U
M$957 \$1116 \$1067 \$1131 GND nfet_03v3 L=0.28U W=1U AS=0.42P AD=0.65P
+ PS=1.84U PD=3.3U
M$958 \$1119 \$1116 GND GND nfet_03v3 L=0.28U W=0.5U AS=0.2425P AD=0.31P
+ PS=1.97U PD=2.24U
M$959 \$1078 \$1119 GND GND nfet_03v3 L=0.28U W=0.5U AS=0.285P AD=0.315P
+ PS=2.14U PD=2.26U
M$960 IPG3 \$1119 E3 GND nfet_03v3 L=0.28U W=1U AS=0.63P AD=0.63P PS=3.26U
+ PD=3.26U
M$961 \$1150 \$1149 GND GND nfet_03v3 L=0.28U W=1U AS=0.76P AD=0.61P PS=3.52U
+ PD=3.22U
M$962 \$1175 \$1150 GND GND nfet_03v3 L=0.28U W=1U AS=0.61P AD=0.61P PS=3.22U
+ PD=3.22U
M$963 \$1151 RSTN \$1175 GND nfet_03v3 L=0.28U W=1U AS=0.61P AD=0.61P PS=3.22U
+ PD=3.22U
M$964 \$1149 \$1154 \$1151 GND nfet_03v3 L=0.28U W=1U AS=0.61P AD=0.61P
+ PS=3.22U PD=3.22U
M$965 \$1176 EN2 \$1149 GND nfet_03v3 L=0.28U W=1U AS=0.61P AD=0.61P PS=3.22U
+ PD=3.22U
M$966 GND \$1148 \$1176 GND nfet_03v3 L=0.28U W=1U AS=0.61P AD=0.575P PS=3.22U
+ PD=3.15U
M$967 GND \$1148 \$1154 GND nfet_03v3 L=0.28U W=1U AS=0.61P AD=0.61P PS=3.22U
+ PD=3.22U
M$968 GND CLK \$1148 GND nfet_03v3 L=0.28U W=1U AS=0.63P AD=0.67P PS=3.26U
+ PD=3.34U
M$969 \$1190 \$19 GND GND nfet_03v3 L=0.28U W=1U AS=0.63P AD=0.42P PS=3.26U
+ PD=1.84U
M$970 \$1155 \$1196 \$1190 GND nfet_03v3 L=0.28U W=1U AS=0.42P AD=0.65P
+ PS=1.84U PD=3.3U
M$971 \$1156 \$1155 GND GND nfet_03v3 L=0.28U W=0.5U AS=0.2425P AD=0.3125P
+ PS=1.97U PD=2.25U
M$972 \$1186 \$1156 GND GND nfet_03v3 L=0.28U W=1U AS=0.63P AD=0.42P PS=3.26U
+ PD=1.84U
M$973 \$1157 \$1158 \$1186 GND nfet_03v3 L=0.28U W=1U AS=0.42P AD=0.65P
+ PS=1.84U PD=3.3U
M$974 \$1159 \$1157 GND GND nfet_03v3 L=0.28U W=0.5U AS=0.2425P AD=0.315P
+ PS=1.97U PD=2.26U
M$975 \$1160 \$1159 GND GND nfet_03v3 L=0.28U W=0.5U AS=0.2825P AD=0.315P
+ PS=2.13U PD=2.26U
M$976 REC2 \$1159 E2 GND nfet_03v3 L=0.28U W=1U AS=0.63P AD=0.63P PS=3.26U
+ PD=3.26U
M$977 \$1192 \$1154 \$1150 GND nfet_03v3 L=0.28U W=1U AS=0.715P AD=0.61P
+ PS=3.43U PD=3.22U
M$978 \$1193 RSTN GND GND nfet_03v3 L=0.28U W=1U AS=0.61P AD=0.61P PS=3.22U
+ PD=3.22U
M$979 \$1194 \$1192 \$1193 GND nfet_03v3 L=0.28U W=1U AS=0.61P AD=0.61P
+ PS=3.22U PD=3.22U
M$980 \$1195 \$1194 \$1192 GND nfet_03v3 L=0.28U W=1U AS=0.61P AD=0.61P
+ PS=3.22U PD=3.22U
M$981 GND \$1148 \$1195 GND nfet_03v3 L=0.28U W=1U AS=0.61P AD=0.61P PS=3.22U
+ PD=3.22U
M$982 \$1196 \$1194 GND GND nfet_03v3 L=0.28U W=1U AS=0.61P AD=0.61P PS=3.22U
+ PD=3.22U
M$983 \$1197 \$1194 GND GND nfet_03v3 L=0.28U W=1U AS=0.61P AD=0.61P PS=3.22U
+ PD=3.22U
M$984 \$1198 \$1197 GND GND nfet_03v3 L=0.28U W=1U AS=0.61P AD=0.61P PS=3.22U
+ PD=3.22U
M$985 \$1216 \$60 GND GND nfet_03v3 L=0.28U W=1U AS=0.63P AD=0.42P PS=3.26U
+ PD=1.84U
M$986 \$1199 \$1196 \$1216 GND nfet_03v3 L=0.28U W=1U AS=0.42P AD=0.65P
+ PS=1.84U PD=3.3U
M$987 \$1200 \$1199 GND GND nfet_03v3 L=0.28U W=0.5U AS=0.2425P AD=0.31P
+ PS=1.97U PD=2.24U
M$988 \$1214 \$1200 GND GND nfet_03v3 L=0.28U W=1U AS=0.63P AD=0.42P PS=3.26U
+ PD=1.84U
M$989 \$1201 \$1160 \$1214 GND nfet_03v3 L=0.28U W=1U AS=0.42P AD=0.65P
+ PS=1.84U PD=3.3U
M$990 \$1202 \$1201 GND GND nfet_03v3 L=0.28U W=0.5U AS=0.2425P AD=0.31P
+ PS=1.97U PD=2.24U
M$991 \$1158 \$1202 GND GND nfet_03v3 L=0.28U W=0.5U AS=0.285P AD=0.315P
+ PS=2.14U PD=2.26U
M$992 IPG2 \$1202 E2 GND nfet_03v3 L=0.28U W=1U AS=0.63P AD=0.63P PS=3.26U
+ PD=3.26U
M$993 \$1234 \$1233 GND GND nfet_03v3 L=0.28U W=1U AS=0.76P AD=0.61P PS=3.52U
+ PD=3.22U
M$994 \$1260 \$1234 GND GND nfet_03v3 L=0.28U W=1U AS=0.61P AD=0.61P PS=3.22U
+ PD=3.22U
M$995 \$1235 RSTN \$1260 GND nfet_03v3 L=0.28U W=1U AS=0.61P AD=0.61P PS=3.22U
+ PD=3.22U
M$996 \$1233 \$1238 \$1235 GND nfet_03v3 L=0.28U W=1U AS=0.61P AD=0.61P
+ PS=3.22U PD=3.22U
M$997 \$1261 EN1 \$1233 GND nfet_03v3 L=0.28U W=1U AS=0.61P AD=0.61P PS=3.22U
+ PD=3.22U
M$998 GND \$1232 \$1261 GND nfet_03v3 L=0.28U W=1U AS=0.61P AD=0.575P PS=3.22U
+ PD=3.15U
M$999 GND \$1232 \$1238 GND nfet_03v3 L=0.28U W=1U AS=0.61P AD=0.61P PS=3.22U
+ PD=3.22U
M$1000 GND CLK \$1232 GND nfet_03v3 L=0.28U W=1U AS=0.63P AD=0.67P PS=3.26U
+ PD=3.34U
M$1001 \$1275 \$19 GND GND nfet_03v3 L=0.28U W=1U AS=0.63P AD=0.42P PS=3.26U
+ PD=1.84U
M$1002 \$1239 \$1259 \$1275 GND nfet_03v3 L=0.28U W=1U AS=0.42P AD=0.65P
+ PS=1.84U PD=3.3U
M$1003 \$1240 \$1239 GND GND nfet_03v3 L=0.28U W=0.5U AS=0.2425P AD=0.3125P
+ PS=1.97U PD=2.25U
M$1004 \$1272 \$1240 GND GND nfet_03v3 L=0.28U W=1U AS=0.63P AD=0.42P PS=3.26U
+ PD=1.84U
M$1005 \$1241 \$1242 \$1272 GND nfet_03v3 L=0.28U W=1U AS=0.42P AD=0.65P
+ PS=1.84U PD=3.3U
M$1006 \$1243 \$1241 GND GND nfet_03v3 L=0.28U W=0.5U AS=0.2425P AD=0.315P
+ PS=1.97U PD=2.26U
M$1007 \$1244 \$1243 GND GND nfet_03v3 L=0.28U W=0.5U AS=0.2825P AD=0.315P
+ PS=2.13U PD=2.26U
M$1008 REC1 \$1243 E1 GND nfet_03v3 L=0.28U W=1U AS=0.63P AD=0.63P PS=3.26U
+ PD=3.26U
M$1009 \$1277 \$1238 \$1234 GND nfet_03v3 L=0.28U W=1U AS=0.715P AD=0.61P
+ PS=3.43U PD=3.22U
M$1010 \$1278 RSTN GND GND nfet_03v3 L=0.28U W=1U AS=0.61P AD=0.61P PS=3.22U
+ PD=3.22U
M$1011 \$1279 \$1277 \$1278 GND nfet_03v3 L=0.28U W=1U AS=0.61P AD=0.61P
+ PS=3.22U PD=3.22U
M$1012 \$1280 \$1279 \$1277 GND nfet_03v3 L=0.28U W=1U AS=0.61P AD=0.61P
+ PS=3.22U PD=3.22U
M$1013 GND \$1232 \$1280 GND nfet_03v3 L=0.28U W=1U AS=0.61P AD=0.61P PS=3.22U
+ PD=3.22U
M$1014 \$1259 \$1279 GND GND nfet_03v3 L=0.28U W=1U AS=0.61P AD=0.61P PS=3.22U
+ PD=3.22U
M$1015 \$1281 \$1279 GND GND nfet_03v3 L=0.28U W=1U AS=0.61P AD=0.61P PS=3.22U
+ PD=3.22U
M$1016 \$1282 \$1281 GND GND nfet_03v3 L=0.28U W=1U AS=0.61P AD=0.61P PS=3.22U
+ PD=3.22U
M$1017 \$1300 \$60 GND GND nfet_03v3 L=0.28U W=1U AS=0.63P AD=0.42P PS=3.26U
+ PD=1.84U
M$1018 \$1283 \$1259 \$1300 GND nfet_03v3 L=0.28U W=1U AS=0.42P AD=0.65P
+ PS=1.84U PD=3.3U
M$1019 \$1286 \$1283 GND GND nfet_03v3 L=0.28U W=0.5U AS=0.2425P AD=0.31P
+ PS=1.97U PD=2.24U
M$1020 \$1298 \$1286 GND GND nfet_03v3 L=0.28U W=1U AS=0.63P AD=0.42P PS=3.26U
+ PD=1.84U
M$1021 \$1284 \$1244 \$1298 GND nfet_03v3 L=0.28U W=1U AS=0.42P AD=0.65P
+ PS=1.84U PD=3.3U
M$1022 \$1287 \$1284 GND GND nfet_03v3 L=0.28U W=0.5U AS=0.2425P AD=0.31P
+ PS=1.97U PD=2.24U
M$1023 \$1242 \$1287 GND GND nfet_03v3 L=0.28U W=0.5U AS=0.285P AD=0.315P
+ PS=2.14U PD=2.26U
M$1024 IPG1 \$1287 E1 GND nfet_03v3 L=0.28U W=1U AS=0.63P AD=0.63P PS=3.26U
+ PD=3.26U
M$1025 \$1318 \$1317 GND GND nfet_03v3 L=0.28U W=1U AS=0.76P AD=0.61P PS=3.52U
+ PD=3.22U
M$1026 \$1343 \$1318 GND GND nfet_03v3 L=0.28U W=1U AS=0.61P AD=0.61P PS=3.22U
+ PD=3.22U
M$1027 \$1319 RSTN \$1343 GND nfet_03v3 L=0.28U W=1U AS=0.61P AD=0.61P PS=3.22U
+ PD=3.22U
M$1028 \$1317 \$1322 \$1319 GND nfet_03v3 L=0.28U W=1U AS=0.61P AD=0.61P
+ PS=3.22U PD=3.22U
M$1029 \$1344 EN0 \$1317 GND nfet_03v3 L=0.28U W=1U AS=0.61P AD=0.61P PS=3.22U
+ PD=3.22U
M$1030 GND \$1316 \$1344 GND nfet_03v3 L=0.28U W=1U AS=0.61P AD=0.575P PS=3.22U
+ PD=3.15U
M$1031 GND \$1316 \$1322 GND nfet_03v3 L=0.28U W=1U AS=0.61P AD=0.61P PS=3.22U
+ PD=3.22U
M$1032 GND CLK \$1316 GND nfet_03v3 L=0.28U W=1U AS=0.63P AD=0.67P PS=3.26U
+ PD=3.34U
M$1033 \$1358 \$19 GND GND nfet_03v3 L=0.28U W=1U AS=0.63P AD=0.42P PS=3.26U
+ PD=1.84U
M$1034 \$1323 \$1364 \$1358 GND nfet_03v3 L=0.28U W=1U AS=0.42P AD=0.65P
+ PS=1.84U PD=3.3U
M$1035 \$1324 \$1323 GND GND nfet_03v3 L=0.28U W=0.5U AS=0.2425P AD=0.3125P
+ PS=1.97U PD=2.25U
M$1036 \$1354 \$1324 GND GND nfet_03v3 L=0.28U W=1U AS=0.63P AD=0.42P PS=3.26U
+ PD=1.84U
M$1037 \$1325 \$1326 \$1354 GND nfet_03v3 L=0.28U W=1U AS=0.42P AD=0.65P
+ PS=1.84U PD=3.3U
M$1038 \$1327 \$1325 GND GND nfet_03v3 L=0.28U W=0.5U AS=0.2425P AD=0.315P
+ PS=1.97U PD=2.26U
M$1039 \$1328 \$1327 GND GND nfet_03v3 L=0.28U W=0.5U AS=0.2825P AD=0.315P
+ PS=2.13U PD=2.26U
M$1040 REC0 \$1327 E0 GND nfet_03v3 L=0.28U W=1U AS=0.63P AD=0.63P PS=3.26U
+ PD=3.26U
M$1041 \$1360 \$1322 \$1318 GND nfet_03v3 L=0.28U W=1U AS=0.715P AD=0.61P
+ PS=3.43U PD=3.22U
M$1042 \$1361 RSTN GND GND nfet_03v3 L=0.28U W=1U AS=0.61P AD=0.61P PS=3.22U
+ PD=3.22U
M$1043 \$1362 \$1360 \$1361 GND nfet_03v3 L=0.28U W=1U AS=0.61P AD=0.61P
+ PS=3.22U PD=3.22U
M$1044 \$1363 \$1362 \$1360 GND nfet_03v3 L=0.28U W=1U AS=0.61P AD=0.61P
+ PS=3.22U PD=3.22U
M$1045 GND \$1316 \$1363 GND nfet_03v3 L=0.28U W=1U AS=0.61P AD=0.61P PS=3.22U
+ PD=3.22U
M$1046 \$1364 \$1362 GND GND nfet_03v3 L=0.28U W=1U AS=0.61P AD=0.61P PS=3.22U
+ PD=3.22U
M$1047 \$1365 \$1362 GND GND nfet_03v3 L=0.28U W=1U AS=0.61P AD=0.61P PS=3.22U
+ PD=3.22U
M$1048 \$1366 \$1365 GND GND nfet_03v3 L=0.28U W=1U AS=0.61P AD=0.61P PS=3.22U
+ PD=3.22U
M$1049 \$1383 \$60 GND GND nfet_03v3 L=0.28U W=1U AS=0.63P AD=0.42P PS=3.26U
+ PD=1.84U
M$1050 \$1367 \$1364 \$1383 GND nfet_03v3 L=0.28U W=1U AS=0.42P AD=0.65P
+ PS=1.84U PD=3.3U
M$1051 \$1368 \$1367 GND GND nfet_03v3 L=0.28U W=0.5U AS=0.2425P AD=0.31P
+ PS=1.97U PD=2.24U
M$1052 \$1385 \$1368 GND GND nfet_03v3 L=0.28U W=1U AS=0.63P AD=0.42P PS=3.26U
+ PD=1.84U
M$1053 \$1369 \$1328 \$1385 GND nfet_03v3 L=0.28U W=1U AS=0.42P AD=0.65P
+ PS=1.84U PD=3.3U
M$1054 \$1370 \$1369 GND GND nfet_03v3 L=0.28U W=0.5U AS=0.2425P AD=0.31P
+ PS=1.97U PD=2.24U
M$1055 \$1326 \$1370 GND GND nfet_03v3 L=0.28U W=0.5U AS=0.285P AD=0.315P
+ PS=2.14U PD=2.26U
M$1056 IPG0 \$1370 E0 GND nfet_03v3 L=0.28U W=1U AS=0.63P AD=0.63P PS=3.26U
+ PD=3.26U
.ENDS FULL
