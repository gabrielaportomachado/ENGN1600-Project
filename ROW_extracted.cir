* Extracted by KLayout with GF180MCU LVS runset on : 23/04/2026 01:33

.SUBCKT ROW GND SW_REC SW_RECb E REC RSTn MODE EN_cfg Qb VDD CLK D SW_IPG
+ SW_IPGb IPG MODEb
M$1 \$3 MODE VDD VDD pfet_03v3 L=0.28U W=1U AS=0.65P AD=0.42P PS=3.3U PD=1.84U
M$2 VDD EN_cfg \$3 VDD pfet_03v3 L=0.28U W=1U AS=0.42P AD=0.735P PS=1.84U
+ PD=2.47U
M$3 SW_REC \$3 VDD VDD pfet_03v3 L=0.28U W=1U AS=0.735P AD=0.64P PS=2.47U
+ PD=3.28U
M$4 SW_RECb SW_REC VDD VDD pfet_03v3 L=0.28U W=1U AS=0.55P AD=0.65P PS=3.1U
+ PD=3.3U
M$5 REC SW_RECb E VDD pfet_03v3 L=0.28U W=1U AS=0.65P AD=0.65P PS=3.3U PD=3.3U
M$6 \$25 \$23 VDD VDD pfet_03v3 L=0.28U W=1U AS=0.65P AD=0.65P PS=3.3U PD=3.3U
M$7 Qb \$25 VDD VDD pfet_03v3 L=0.28U W=1U AS=0.65P AD=0.65P PS=3.3U PD=3.3U
M$8 \$2 CLK VDD VDD pfet_03v3 L=0.28U W=1U AS=0.65P AD=0.65P PS=3.3U PD=3.3U
M$9 \$16 \$2 VDD VDD pfet_03v3 L=0.28U W=1U AS=0.65P AD=0.65P PS=3.3U PD=3.3U
M$10 \$58 \$16 VDD VDD pfet_03v3 L=0.28U W=1U AS=0.65P AD=0.65P PS=3.3U PD=3.3U
M$11 \$23 RSTn VDD VDD pfet_03v3 L=0.28U W=1U AS=0.65P AD=0.65P PS=3.3U PD=3.3U
M$12 \$23 \$12 VDD VDD pfet_03v3 L=0.28U W=1U AS=0.65P AD=0.65P PS=3.3U PD=3.3U
M$13 \$59 \$23 \$12 VDD pfet_03v3 L=0.28U W=1U AS=0.65P AD=0.65P PS=3.3U PD=3.3U
M$14 VDD \$16 \$59 VDD pfet_03v3 L=0.28U W=1U AS=0.65P AD=0.65P PS=3.3U PD=3.3U
M$15 EN_cfg \$23 VDD VDD pfet_03v3 L=0.28U W=1U AS=0.65P AD=0.65P PS=3.3U
+ PD=3.3U
M$16 \$18 D \$58 VDD pfet_03v3 L=0.28U W=1U AS=0.65P AD=0.65P PS=3.3U PD=3.3U
M$17 \$19 \$2 \$18 VDD pfet_03v3 L=0.28U W=1U AS=0.65P AD=0.65P PS=3.3U PD=3.3U
M$18 VDD RSTn \$19 VDD pfet_03v3 L=0.28U W=1U AS=0.65P AD=0.65P PS=3.3U PD=3.3U
M$19 \$19 \$21 VDD VDD pfet_03v3 L=0.28U W=1U AS=0.65P AD=0.65P PS=3.3U PD=3.3U
M$20 VDD \$18 \$21 VDD pfet_03v3 L=0.28U W=1U AS=0.65P AD=0.65P PS=3.3U PD=3.3U
M$21 \$12 \$2 \$21 VDD pfet_03v3 L=0.28U W=1U AS=0.65P AD=0.65P PS=3.3U PD=3.3U
M$22 \$31 MODEb VDD VDD pfet_03v3 L=0.28U W=1U AS=0.65P AD=0.42P PS=3.3U
+ PD=1.84U
M$23 VDD EN_cfg \$31 VDD pfet_03v3 L=0.28U W=1U AS=0.42P AD=0.735P PS=1.84U
+ PD=2.47U
M$24 SW_IPG \$31 VDD VDD pfet_03v3 L=0.28U W=1U AS=0.735P AD=0.63P PS=2.47U
+ PD=3.26U
M$25 SW_IPGb SW_IPG VDD VDD pfet_03v3 L=0.28U W=1U AS=0.56P AD=0.65P PS=3.12U
+ PD=3.3U
M$26 IPG SW_IPGb E VDD pfet_03v3 L=0.28U W=1U AS=0.65P AD=0.65P PS=3.3U PD=3.3U
M$27 SW_REC \$3 GND GND nfet_03v3 L=0.28U W=0.5U AS=0.2425P AD=0.3125P PS=1.97U
+ PD=2.25U
M$28 SW_RECb SW_REC GND GND nfet_03v3 L=0.28U W=0.5U AS=0.2825P AD=0.315P
+ PS=2.13U PD=2.26U
M$29 \$2 CLK GND GND nfet_03v3 L=0.28U W=1U AS=0.61P AD=0.61P PS=3.22U PD=3.22U
M$30 \$16 \$2 GND GND nfet_03v3 L=0.28U W=1U AS=0.61P AD=0.61P PS=3.22U PD=3.22U
M$31 GND \$2 \$24 GND nfet_03v3 L=0.28U W=1U AS=0.61P AD=0.61P PS=3.22U PD=3.22U
M$32 \$17 \$2 GND GND nfet_03v3 L=0.28U W=1U AS=0.61P AD=0.61P PS=3.22U PD=3.22U
M$33 \$25 \$23 GND GND nfet_03v3 L=0.28U W=1U AS=0.61P AD=0.61P PS=3.22U
+ PD=3.22U
M$34 Qb \$25 GND GND nfet_03v3 L=0.28U W=1U AS=0.61P AD=0.61P PS=3.22U PD=3.22U
M$35 \$19 \$16 \$18 GND nfet_03v3 L=0.28U W=1U AS=0.61P AD=0.61P PS=3.22U
+ PD=3.22U
M$36 \$12 \$16 \$21 GND nfet_03v3 L=0.28U W=1U AS=0.61P AD=0.61P PS=3.22U
+ PD=3.22U
M$37 \$22 RSTn GND GND nfet_03v3 L=0.28U W=1U AS=0.61P AD=0.61P PS=3.22U
+ PD=3.22U
M$38 \$23 \$12 \$22 GND nfet_03v3 L=0.28U W=1U AS=0.61P AD=0.61P PS=3.22U
+ PD=3.22U
M$39 \$24 \$23 \$12 GND nfet_03v3 L=0.28U W=1U AS=0.61P AD=0.61P PS=3.22U
+ PD=3.22U
M$40 EN_cfg \$23 GND GND nfet_03v3 L=0.28U W=1U AS=0.61P AD=0.61P PS=3.22U
+ PD=3.22U
M$41 \$18 D \$17 GND nfet_03v3 L=0.28U W=1U AS=0.61P AD=0.61P PS=3.22U PD=3.22U
M$42 \$20 RSTn \$19 GND nfet_03v3 L=0.28U W=1U AS=0.61P AD=0.61P PS=3.22U
+ PD=3.22U
M$43 GND \$21 \$20 GND nfet_03v3 L=0.28U W=1U AS=0.61P AD=0.61P PS=3.22U
+ PD=3.22U
M$44 GND \$18 \$21 GND nfet_03v3 L=0.28U W=1U AS=0.61P AD=0.61P PS=3.22U
+ PD=3.22U
M$45 \$44 MODE GND GND nfet_03v3 L=0.28U W=1U AS=0.63P AD=0.42P PS=3.26U
+ PD=1.84U
M$46 \$3 EN_cfg \$44 GND nfet_03v3 L=0.28U W=1U AS=0.42P AD=0.65P PS=1.84U
+ PD=3.3U
M$47 REC SW_REC E GND nfet_03v3 L=0.28U W=1U AS=0.63P AD=0.63P PS=3.26U PD=3.26U
M$48 \$70 MODEb GND GND nfet_03v3 L=0.28U W=1U AS=0.63P AD=0.42P PS=3.26U
+ PD=1.84U
M$49 \$31 EN_cfg \$70 GND nfet_03v3 L=0.28U W=1U AS=0.42P AD=0.65P PS=1.84U
+ PD=3.3U
M$50 SW_IPG \$31 GND GND nfet_03v3 L=0.28U W=0.5U AS=0.2425P AD=0.31P PS=1.97U
+ PD=2.24U
M$51 SW_IPGb SW_IPG GND GND nfet_03v3 L=0.28U W=0.5U AS=0.285P AD=0.315P
+ PS=2.14U PD=2.26U
M$52 IPG SW_IPG E GND nfet_03v3 L=0.28U W=1U AS=0.63P AD=0.63P PS=3.26U PD=3.26U
.ENDS ROW
