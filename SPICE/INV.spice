** sch_path: /foss/designs/project/AND/INV.sch
.subckt INV OUT IN
*.PININFO IN:I OUT:O
M1 OUT IN VDD VDD pfet_03v3 L=0.28u W=1u nf=1 m=1
M2 OUT IN GND GND nfet_03v3 L=0.28u W=0.5u nf=1 m=1
.ends
.GLOBAL VDD
.GLOBAL GND
